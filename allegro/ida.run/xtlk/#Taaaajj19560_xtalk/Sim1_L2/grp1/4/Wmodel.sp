*Wmodel Definition*
*TraceModel Definition*

.Model Wmodel_Trace117::HDMI_DATA0_P W MODELTYPE=RLGC N=1
+ Lo=
+ 3.32029740e-07
+ Co=
+ 1.03489020e-10
+ Ro=
+ 3.96831067e+00
+ Go=
+ 0.00000000e+00
+ Rs=
+ 1.55902417e-03
+ Gd=
+ 2.04067990e-11

.Model Wmodel_Trace118::HDMI_DATA0_P W MODELTYPE=RLGC N=1
+ Lo=
+ 3.32029740e-07
+ Co=
+ 1.03489020e-10
+ Ro=
+ 3.96831067e+00
+ Go=
+ 0.00000000e+00
+ Rs=
+ 1.55902417e-03
+ Gd=
+ 2.04067990e-11

.Model Wmodel_Trace119::HDMI_DATA0_P W MODELTYPE=RLGC N=1
+ Lo=
+ 3.32029740e-07
+ Co=
+ 1.03489020e-10
+ Ro=
+ 3.96831067e+00
+ Go=
+ 0.00000000e+00
+ Rs=
+ 1.55902417e-03
+ Gd=
+ 2.04067990e-11

.Model Wmodel_Trace147_Auto_4::HDMI_DATA0_P W MODELTYPE=RLGC N=1
+ Lo=
+ 3.32029740e-07
+ Co=
+ 1.03489020e-10
+ Ro=
+ 3.96831067e+00
+ Go=
+ 0.00000000e+00
+ Rs=
+ 1.55902417e-03
+ Gd=
+ 2.04067990e-11

.Model Wmodel_Trace148::HDMI_DATA0_P W MODELTYPE=RLGC N=1
+ Lo=
+ 3.32029740e-07
+ Co=
+ 1.03489020e-10
+ Ro=
+ 3.96831067e+00
+ Go=
+ 0.00000000e+00
+ Rs=
+ 1.55902417e-03
+ Gd=
+ 2.04067990e-11

.Model Wmodel_Trace156::HDMI_DATA0_P W MODELTYPE=RLGC N=1
+ Lo=
+ 3.32029740e-07
+ Co=
+ 1.03489020e-10
+ Ro=
+ 3.96831067e+00
+ Go=
+ 0.00000000e+00
+ Rs=
+ 1.55902417e-03
+ Gd=
+ 2.04067990e-11

.Model Wmodel_Trace166::HDMI_DATA1_P W MODELTYPE=RLGC N=1
+ Lo=
+ 3.32029740e-07
+ Co=
+ 1.03489020e-10
+ Ro=
+ 3.96831067e+00
+ Go=
+ 0.00000000e+00
+ Rs=
+ 1.55902417e-03
+ Gd=
+ 2.04067990e-11

.Model Wmodel_Trace168_Auto_52::HDMI_DATA1_P W MODELTYPE=RLGC N=1
+ Lo=
+ 3.32029740e-07
+ Co=
+ 1.03489020e-10
+ Ro=
+ 3.96831067e+00
+ Go=
+ 0.00000000e+00
+ Rs=
+ 1.55902417e-03
+ Gd=
+ 2.04067990e-11

.Model Wmodel_Trace170::HDMI_DATA1_P W MODELTYPE=RLGC N=1
+ Lo=
+ 3.32029740e-07
+ Co=
+ 1.03489020e-10
+ Ro=
+ 3.96831067e+00
+ Go=
+ 0.00000000e+00
+ Rs=
+ 1.55902417e-03
+ Gd=
+ 2.04067990e-11

.Model Wmodel_Trace172_Auto_16::HDMI_DATA1_P W MODELTYPE=RLGC N=1
+ Lo=
+ 3.32029740e-07
+ Co=
+ 1.03489020e-10
+ Ro=
+ 3.96831067e+00
+ Go=
+ 0.00000000e+00
+ Rs=
+ 1.55902417e-03
+ Gd=
+ 2.04067990e-11

.Model Wmodel_Trace215::HDMI_DATA1_P W MODELTYPE=RLGC N=1
+ Lo=
+ 3.32029740e-07
+ Co=
+ 1.03489020e-10
+ Ro=
+ 3.96831067e+00
+ Go=
+ 0.00000000e+00
+ Rs=
+ 1.55902417e-03
+ Gd=
+ 2.04067990e-11

.Model Wmodel_Trace217_Auto_31::HDMI_DATA1_P W MODELTYPE=RLGC N=1
+ Lo=
+ 3.32029740e-07
+ Co=
+ 1.03489020e-10
+ Ro=
+ 3.96831067e+00
+ Go=
+ 0.00000000e+00
+ Rs=
+ 1.55902417e-03
+ Gd=
+ 2.04067990e-11

.Model Wmodel_Trace219::HDMI_DATA1_P W MODELTYPE=RLGC N=1
+ Lo=
+ 3.32029740e-07
+ Co=
+ 1.03489020e-10
+ Ro=
+ 3.96831067e+00
+ Go=
+ 0.00000000e+00
+ Rs=
+ 1.55902417e-03
+ Gd=
+ 2.04067990e-11

.Model Wmodel_Trace221::HDMI_DATA1_P W MODELTYPE=RLGC N=1
+ Lo=
+ 3.32029740e-07
+ Co=
+ 1.03489020e-10
+ Ro=
+ 3.96831067e+00
+ Go=
+ 0.00000000e+00
+ Rs=
+ 1.55902417e-03
+ Gd=
+ 2.04067990e-11

.Model Wmodel_Trace221_Auto_33::HDMI_DATA1_P W MODELTYPE=RLGC N=1
+ Lo=
+ 3.32029740e-07
+ Co=
+ 1.03489020e-10
+ Ro=
+ 3.96831067e+00
+ Go=
+ 0.00000000e+00
+ Rs=
+ 1.55902417e-03
+ Gd=
+ 2.04067990e-11

.Model Wmodel_Trace223::HDMI_DATA1_P W MODELTYPE=RLGC N=1
+ Lo=
+ 3.32029740e-07
+ Co=
+ 1.03489020e-10
+ Ro=
+ 3.96831067e+00
+ Go=
+ 0.00000000e+00
+ Rs=
+ 1.55902417e-03
+ Gd=
+ 2.04067990e-11

.Model Wmodel_Trace233::HDMI_DATA0_N W MODELTYPE=RLGC N=1
+ Lo=
+ 3.32029740e-07
+ Co=
+ 1.03489020e-10
+ Ro=
+ 3.96831067e+00
+ Go=
+ 0.00000000e+00
+ Rs=
+ 1.55902417e-03
+ Gd=
+ 2.04067990e-11

.Model Wmodel_Trace236::HDMI_DATA0_N W MODELTYPE=RLGC N=1
+ Lo=
+ 3.32029740e-07
+ Co=
+ 1.03489020e-10
+ Ro=
+ 3.96831067e+00
+ Go=
+ 0.00000000e+00
+ Rs=
+ 1.55902417e-03
+ Gd=
+ 2.04067990e-11

.Model Wmodel_Trace238::HDMI_DATA0_N W MODELTYPE=RLGC N=1
+ Lo=
+ 3.32029740e-07
+ Co=
+ 1.03489020e-10
+ Ro=
+ 3.96831067e+00
+ Go=
+ 0.00000000e+00
+ Rs=
+ 1.55902417e-03
+ Gd=
+ 2.04067990e-11

.Model Wmodel_Trace238_Auto_36::HDMI_DATA0_N W MODELTYPE=RLGC N=3
+ Lo=
+ 3.30674605e-07
+ 4.18614915e-08 3.29416343e-07
+ 1.20912331e-08 4.27913181e-08 3.30607138e-07
+ Co=
+ 1.03813079e-10
+ -4.48146365e-12 1.04142944e-10
+ -5.46293114e-13 -4.64006740e-12 1.03835093e-10
+ Ro=
+ 3.96831067e+00
+ 0.00000000e+00 3.96831067e+00
+ 0.00000000e+00 0.00000000e+00 3.96831067e+00
+ Go=
+ 0.00000000e+00
+ -0.00000000e+00 0.00000000e+00
+ -0.00000000e+00 -0.00000000e+00 0.00000000e+00
+ Rs=
+ 1.55902417e-03
+ -0.00000000e+00 1.55902417e-03
+ -0.00000000e+00 -0.00000000e+00 1.55902417e-03
+ Gd=
+ 2.03820142e-11
+ -1.79552246e-13 2.03592566e-11
+ -0.00000000e+00 -1.95407241e-13 2.03814878e-11

.Model Wmodel_Trace238_Auto_37::HDMI_DATA0_N W MODELTYPE=RLGC N=2
+ Lo=
+ 3.30748904e-07
+ 4.21593990e-08 3.30748904e-07
+ Co=
+ 1.03807716e-10
+ -4.52055469e-12 1.03807716e-10
+ Ro=
+ 3.96831067e+00
+ 0.00000000e+00 3.96831067e+00
+ Go=
+ 0.00000000e+00
+ -0.00000000e+00 0.00000000e+00
+ Rs=
+ 1.55902417e-03
+ -0.00000000e+00 1.55902417e-03
+ Gd=
+ 2.03827260e-11
+ -1.75097034e-13 2.03827260e-11

.Model Wmodel_Trace238_Auto_38::HDMI_DATA0_N W MODELTYPE=RLGC N=1
+ Lo=
+ 3.32029740e-07
+ Co=
+ 1.03489020e-10
+ Ro=
+ 3.96831067e+00
+ Go=
+ 0.00000000e+00
+ Rs=
+ 1.55902417e-03
+ Gd=
+ 2.04067990e-11

.Model Wmodel_Trace239::HDMI_DATA0_N W MODELTYPE=RLGC N=1
+ Lo=
+ 3.32029740e-07
+ Co=
+ 1.03489020e-10
+ Ro=
+ 3.96831067e+00
+ Go=
+ 0.00000000e+00
+ Rs=
+ 1.55902417e-03
+ Gd=
+ 2.04067990e-11

.Model Wmodel_Trace261::HDMI_DATA0_N W MODELTYPE=RLGC N=1
+ Lo=
+ 3.32029740e-07
+ Co=
+ 1.03489020e-10
+ Ro=
+ 3.96831067e+00
+ Go=
+ 0.00000000e+00
+ Rs=
+ 1.55902417e-03
+ Gd=
+ 2.04067990e-11

.Model Wmodel_Trace261_Auto_3::HDMI_DATA0_N W MODELTYPE=RLGC N=2
+ Lo=
+ 3.31343957e-07
+ 3.23331185e-08 3.31343957e-07
+ Co=
+ 1.03631941e-10
+ -2.99339872e-12 1.03631941e-10
+ Ro=
+ 3.96831067e+00
+ 0.00000000e+00 3.96831067e+00
+ Go=
+ 0.00000000e+00
+ -0.00000000e+00 0.00000000e+00
+ Rs=
+ 1.55902417e-03
+ -0.00000000e+00 1.55902417e-03
+ Gd=
+ 2.03905441e-11
+ -4.01529324e-14 2.03905441e-11

.Model Wmodel_Trace263::HDMI_DATA0_N W MODELTYPE=RLGC N=1
+ Lo=
+ 3.32029740e-07
+ Co=
+ 1.03489020e-10
+ Ro=
+ 3.96831067e+00
+ Go=
+ 0.00000000e+00
+ Rs=
+ 1.55902417e-03
+ Gd=
+ 2.04067990e-11

.Model Wmodel_Trace264::HDMI_DATA0_N W MODELTYPE=RLGC N=1
+ Lo=
+ 3.32029740e-07
+ Co=
+ 1.03489020e-10
+ Ro=
+ 3.96831067e+00
+ Go=
+ 0.00000000e+00
+ Rs=
+ 1.55902417e-03
+ Gd=
+ 2.04067990e-11

.Model Wmodel_Trace264_Auto_5::HDMI_DATA0_N W MODELTYPE=RLGC N=2
+ Lo=
+ 3.30779224e-07
+ 4.17351605e-08 3.30779224e-07
+ Co=
+ 1.03797942e-10
+ -4.44896878e-12 1.03797942e-10
+ Ro=
+ 3.96831067e+00
+ 0.00000000e+00 3.96831067e+00
+ Go=
+ 0.00000000e+00
+ -0.00000000e+00 0.00000000e+00
+ Rs=
+ 1.55902417e-03
+ -0.00000000e+00 1.55902417e-03
+ Gd=
+ 2.03829849e-11
+ -1.67949167e-13 2.03829849e-11

.Model Wmodel_Trace268::HDMI_DATA0_N W MODELTYPE=RLGC N=1
+ Lo=
+ 3.32029740e-07
+ Co=
+ 1.03489020e-10
+ Ro=
+ 3.96831067e+00
+ Go=
+ 0.00000000e+00
+ Rs=
+ 1.55902417e-03
+ Gd=
+ 2.04067990e-11

.Model Wmodel_Trace278::HDMI_CLK_P W MODELTYPE=RLGC N=1
+ Lo=
+ 3.32029740e-07
+ Co=
+ 1.03489020e-10
+ Ro=
+ 3.96831067e+00
+ Go=
+ 0.00000000e+00
+ Rs=
+ 1.55902417e-03
+ Gd=
+ 2.04067990e-11

.Model Wmodel_Trace280_Auto_40::HDMI_CLK_P W MODELTYPE=RLGC N=5
+ Lo=
+ 3.30701692e-07
+ 4.12731360e-08 3.29429019e-07
+ 1.17003635e-08 4.15073831e-08 3.28990399e-07
+ 5.34228846e-09 1.24528563e-08 4.59773315e-08 3.29045518e-07
+ 2.95751231e-09 5.36951905e-09 1.25505834e-08 4.17995865e-08 3.30647995e-07
+ Co=
+ 1.03801289e-10
+ -4.38524164e-12 1.04114703e-10
+ -5.18609589e-13 -4.43772744e-12 1.04246836e-10
+ -2.27159287e-13 -5.32529321e-13 -5.22322531e-12 1.04243457e-10
+ -1.32682944e-13 -2.31165814e-13 -5.46570058e-13 -4.47632666e-12 1.03815335e-10
+ Ro=
+ 3.96831067e+00
+ 0.00000000e+00 3.96831067e+00
+ 0.00000000e+00 0.00000000e+00 3.96831067e+00
+ 0.00000000e+00 0.00000000e+00 0.00000000e+00 3.96831067e+00
+ 0.00000000e+00 0.00000000e+00 0.00000000e+00 0.00000000e+00 3.96831067e+00
+ Go=
+ 0.00000000e+00
+ -0.00000000e+00 0.00000000e+00
+ -0.00000000e+00 -0.00000000e+00 0.00000000e+00
+ -0.00000000e+00 -0.00000000e+00 -0.00000000e+00 0.00000000e+00
+ -0.00000000e+00 -0.00000000e+00 -0.00000000e+00 -0.00000000e+00 0.00000000e+00
+ Rs=
+ 1.55902417e-03
+ -0.00000000e+00 1.55902417e-03
+ -0.00000000e+00 -0.00000000e+00 1.55902417e-03
+ -0.00000000e+00 -0.00000000e+00 -0.00000000e+00 1.55902417e-03
+ -0.00000000e+00 -0.00000000e+00 -0.00000000e+00 -0.00000000e+00 1.55902417e-03
+ Gd=
+ 2.03821998e-11
+ -1.70308166e-13 2.03592714e-11
+ -0.00000000e+00 -1.84295961e-13 2.03566465e-11
+ -0.00000000e+00 -0.00000000e+00 -2.66072039e-13 2.03571312e-11
+ -0.00000000e+00 -0.00000000e+00 -0.00000000e+00 -1.80765662e-13 2.03817834e-11

.Model Wmodel_Trace323::HDMI_CLK_P W MODELTYPE=RLGC N=1
+ Lo=
+ 3.32029740e-07
+ Co=
+ 1.03489020e-10
+ Ro=
+ 3.96831067e+00
+ Go=
+ 0.00000000e+00
+ Rs=
+ 1.55902417e-03
+ Gd=
+ 2.04067990e-11

.Model Wmodel_Trace325::HDMI_CLK_P W MODELTYPE=RLGC N=1
+ Lo=
+ 3.32029740e-07
+ Co=
+ 1.03489020e-10
+ Ro=
+ 3.96831067e+00
+ Go=
+ 0.00000000e+00
+ Rs=
+ 1.55902417e-03
+ Gd=
+ 2.04067990e-11

.Model Wmodel_Trace327::HDMI_CLK_P W MODELTYPE=RLGC N=1
+ Lo=
+ 3.32029740e-07
+ Co=
+ 1.03489020e-10
+ Ro=
+ 3.96831067e+00
+ Go=
+ 0.00000000e+00
+ Rs=
+ 1.55902417e-03
+ Gd=
+ 2.04067990e-11

.Model Wmodel_Trace329_Auto_126::HDMI_CLK_P W MODELTYPE=RLGC N=1
+ Lo=
+ 3.32029740e-07
+ Co=
+ 1.03489020e-10
+ Ro=
+ 3.96831067e+00
+ Go=
+ 0.00000000e+00
+ Rs=
+ 1.55902417e-03
+ Gd=
+ 2.04067990e-11

.Model Wmodel_Trace330::HDMI_CLK_P W MODELTYPE=RLGC N=1
+ Lo=
+ 3.32029740e-07
+ Co=
+ 1.03489020e-10
+ Ro=
+ 3.96831067e+00
+ Go=
+ 0.00000000e+00
+ Rs=
+ 1.55902417e-03
+ Gd=
+ 2.04067990e-11

.Model Wmodel_Trace348::HDMI_DATA1_N W MODELTYPE=RLGC N=1
+ Lo=
+ 3.32029740e-07
+ Co=
+ 1.03489020e-10
+ Ro=
+ 3.96831067e+00
+ Go=
+ 0.00000000e+00
+ Rs=
+ 1.55902417e-03
+ Gd=
+ 2.04067990e-11

.Model Wmodel_Trace351::HDMI_DATA1_N W MODELTYPE=RLGC N=1
+ Lo=
+ 3.32029740e-07
+ Co=
+ 1.03489020e-10
+ Ro=
+ 3.96831067e+00
+ Go=
+ 0.00000000e+00
+ Rs=
+ 1.55902417e-03
+ Gd=
+ 2.04067990e-11

.Model Wmodel_Trace353_Auto_44::HDMI_DATA1_N W MODELTYPE=RLGC N=1
+ Lo=
+ 3.32029740e-07
+ Co=
+ 1.03489020e-10
+ Ro=
+ 3.96831067e+00
+ Go=
+ 0.00000000e+00
+ Rs=
+ 1.55902417e-03
+ Gd=
+ 2.04067990e-11

.Model Wmodel_Trace353_Auto_51::HDMI_DATA1_N W MODELTYPE=RLGC N=1
+ Lo=
+ 3.32029740e-07
+ Co=
+ 1.03489020e-10
+ Ro=
+ 3.96831067e+00
+ Go=
+ 0.00000000e+00
+ Rs=
+ 1.55902417e-03
+ Gd=
+ 2.04067990e-11

.Model Wmodel_Trace355::HDMI_DATA1_N W MODELTYPE=RLGC N=1
+ Lo=
+ 3.32029740e-07
+ Co=
+ 1.03489020e-10
+ Ro=
+ 3.96831067e+00
+ Go=
+ 0.00000000e+00
+ Rs=
+ 1.55902417e-03
+ Gd=
+ 2.04067990e-11

.Model Wmodel_Trace357::HDMI_DATA1_N W MODELTYPE=RLGC N=1
+ Lo=
+ 3.32029740e-07
+ Co=
+ 1.03489020e-10
+ Ro=
+ 3.96831067e+00
+ Go=
+ 0.00000000e+00
+ Rs=
+ 1.55902417e-03
+ Gd=
+ 2.04067990e-11

.Model Wmodel_Trace357_Auto_15::HDMI_DATA1_N W MODELTYPE=RLGC N=2
+ Lo=
+ 3.30784317e-07
+ 4.16632978e-08 3.30784317e-07
+ Co=
+ 1.03796308e-10
+ -4.43689152e-12 1.03796308e-10
+ Ro=
+ 3.96831067e+00
+ 0.00000000e+00 3.96831067e+00
+ Go=
+ 0.00000000e+00
+ -0.00000000e+00 0.00000000e+00
+ Rs=
+ 1.55902417e-03
+ -0.00000000e+00 1.55902417e-03
+ Gd=
+ 2.03830298e-11
+ -1.66749822e-13 2.03830298e-11

.Model Wmodel_Trace377::HDMI_DATA1_N W MODELTYPE=RLGC N=1
+ Lo=
+ 3.32029740e-07
+ Co=
+ 1.03489020e-10
+ Ro=
+ 3.96831067e+00
+ Go=
+ 0.00000000e+00
+ Rs=
+ 1.55902417e-03
+ Gd=
+ 2.04067990e-11

.Model Wmodel_Trace379::HDMI_DATA1_N W MODELTYPE=RLGC N=1
+ Lo=
+ 3.32029740e-07
+ Co=
+ 1.03489020e-10
+ Ro=
+ 3.96831067e+00
+ Go=
+ 0.00000000e+00
+ Rs=
+ 1.55902417e-03
+ Gd=
+ 2.04067990e-11

.Model Wmodel_Trace379_Auto_30::HDMI_DATA1_N W MODELTYPE=RLGC N=2
+ Lo=
+ 3.30797598e-07
+ 4.14750767e-08 3.30797598e-07
+ Co=
+ 1.03792058e-10
+ -4.40532628e-12 1.03792058e-10
+ Ro=
+ 3.96831067e+00
+ 0.00000000e+00 3.96831067e+00
+ Go=
+ 0.00000000e+00
+ -0.00000000e+00 0.00000000e+00
+ Rs=
+ 1.55902417e-03
+ -0.00000000e+00 1.55902417e-03
+ Gd=
+ 2.03831488e-11
+ -1.63624287e-13 2.03831488e-11

.Model Wmodel_Trace381::HDMI_DATA1_N W MODELTYPE=RLGC N=1
+ Lo=
+ 3.32029740e-07
+ Co=
+ 1.03489020e-10
+ Ro=
+ 3.96831067e+00
+ Go=
+ 0.00000000e+00
+ Rs=
+ 1.55902417e-03
+ Gd=
+ 2.04067990e-11

.Model Wmodel_Trace383::HDMI_DATA1_N W MODELTYPE=RLGC N=2
+ Lo=
+ 3.30739043e-07
+ 4.22960763e-08 3.30739043e-07
+ Co=
+ 1.03810911e-10
+ -4.54372237e-12 1.03810911e-10
+ Ro=
+ 3.96831067e+00
+ 0.00000000e+00 3.96831067e+00
+ Go=
+ 0.00000000e+00
+ -0.00000000e+00 0.00000000e+00
+ Rs=
+ 1.55902417e-03
+ -0.00000000e+00 1.55902417e-03
+ Gd=
+ 2.03826449e-11
+ -1.77424428e-13 2.03826449e-11

.Model Wmodel_Trace391::HDMI_DATA1_N W MODELTYPE=RLGC N=1
+ Lo=
+ 3.32029740e-07
+ Co=
+ 1.03489020e-10
+ Ro=
+ 3.96831067e+00
+ Go=
+ 0.00000000e+00
+ Rs=
+ 1.55902417e-03
+ Gd=
+ 2.04067990e-11

.Model Wmodel_Trace401::HDMI_CLK_N W MODELTYPE=RLGC N=1
+ Lo=
+ 3.32029740e-07
+ Co=
+ 1.03489020e-10
+ Ro=
+ 3.96831067e+00
+ Go=
+ 0.00000000e+00
+ Rs=
+ 1.55902417e-03
+ Gd=
+ 2.04067990e-11

.Model Wmodel_Trace404::HDMI_CLK_N W MODELTYPE=RLGC N=1
+ Lo=
+ 3.32029740e-07
+ Co=
+ 1.03489020e-10
+ Ro=
+ 3.96831067e+00
+ Go=
+ 0.00000000e+00
+ Rs=
+ 1.55902417e-03
+ Gd=
+ 2.04067990e-11

.Model Wmodel_Trace406::HDMI_CLK_N W MODELTYPE=RLGC N=1
+ Lo=
+ 3.32029740e-07
+ Co=
+ 1.03489020e-10
+ Ro=
+ 3.96831067e+00
+ Go=
+ 0.00000000e+00
+ Rs=
+ 1.55902417e-03
+ Gd=
+ 2.04067990e-11

.Model Wmodel_Trace406_Auto_39::HDMI_CLK_N W MODELTYPE=RLGC N=6
+ Lo=
+ 3.30781609e-07
+ 4.01890428e-08 3.29552207e-07
+ 1.14347754e-08 4.10122412e-08 3.29363823e-07
+ 5.03619903e-09 1.16002621e-08 4.14718474e-08 3.28979895e-07
+ 2.89123503e-09 5.29032887e-09 1.24367202e-08 4.59712502e-08 3.29042051e-07
+ 1.84756411e-09 2.92658634e-09 5.36014236e-09 1.25467474e-08 4.17973981e-08 3.30646609e-07
+ Co=
+ 1.03777044e-10
+ -4.20403018e-12 1.04077777e-10
+ -5.12183792e-13 -4.35171561e-12 1.04119195e-10
+ -2.17337540e-13 -5.04632624e-13 -4.43421602e-12 1.04247474e-10
+ -1.24454176e-13 -2.19249261e-13 -5.31341372e-13 -5.22275658e-12 1.04243733e-10
+ -8.40913692e-14 -1.27385903e-13 -2.30386204e-13 -5.46248943e-13 -4.47613970e-12 1.03815461e-10
+ Ro=
+ 3.96831067e+00
+ 0.00000000e+00 3.96831067e+00
+ 0.00000000e+00 0.00000000e+00 3.96831067e+00
+ 0.00000000e+00 0.00000000e+00 0.00000000e+00 3.96831067e+00
+ 0.00000000e+00 0.00000000e+00 0.00000000e+00 0.00000000e+00 3.96831067e+00
+ 0.00000000e+00 0.00000000e+00 0.00000000e+00 0.00000000e+00 0.00000000e+00 3.96831067e+00
+ Go=
+ 0.00000000e+00
+ -0.00000000e+00 0.00000000e+00
+ -0.00000000e+00 -0.00000000e+00 0.00000000e+00
+ -0.00000000e+00 -0.00000000e+00 -0.00000000e+00 0.00000000e+00
+ -0.00000000e+00 -0.00000000e+00 -0.00000000e+00 -0.00000000e+00 0.00000000e+00
+ -0.00000000e+00 -0.00000000e+00 -0.00000000e+00 -0.00000000e+00 -0.00000000e+00 0.00000000e+00
+ Rs=
+ 1.55902417e-03
+ -0.00000000e+00 1.55902417e-03
+ -0.00000000e+00 -0.00000000e+00 1.55902417e-03
+ -0.00000000e+00 -0.00000000e+00 -0.00000000e+00 1.55902417e-03
+ -0.00000000e+00 -0.00000000e+00 -0.00000000e+00 -0.00000000e+00 1.55902417e-03
+ -0.00000000e+00 -0.00000000e+00 -0.00000000e+00 -0.00000000e+00 -0.00000000e+00 1.55902417e-03
+ Gd=
+ 2.03829338e-11
+ -1.52344307e-13 2.03602896e-11
+ -0.00000000e+00 -1.74171975e-13 2.03586706e-11
+ -0.00000000e+00 -0.00000000e+00 -1.84397790e-13 2.03565432e-11
+ -0.00000000e+00 -0.00000000e+00 -0.00000000e+00 -2.66133151e-13 2.03570954e-11
+ -0.00000000e+00 -0.00000000e+00 -0.00000000e+00 -0.00000000e+00 -1.80790891e-13 2.03817657e-11

.Model Wmodel_Trace440::HDMI_CLK_N W MODELTYPE=RLGC N=1
+ Lo=
+ 3.32029740e-07
+ Co=
+ 1.03489020e-10
+ Ro=
+ 3.96831067e+00
+ Go=
+ 0.00000000e+00
+ Rs=
+ 1.55902417e-03
+ Gd=
+ 2.04067990e-11

.Model Wmodel_Trace443::HDMI_CLK_N W MODELTYPE=RLGC N=2
+ Lo=
+ 3.31143029e-07
+ 3.60773784e-08 3.31143029e-07
+ Co=
+ 1.03687221e-10
+ -3.54237837e-12 1.03687221e-10
+ Ro=
+ 3.96831067e+00
+ 0.00000000e+00 3.96831067e+00
+ Go=
+ 0.00000000e+00
+ -0.00000000e+00 0.00000000e+00
+ Rs=
+ 1.55902417e-03
+ -0.00000000e+00 1.55902417e-03
+ Gd=
+ 2.03872385e-11
+ -8.38951310e-14 2.03872385e-11

.Model Wmodel_Trace446::HDMI_CLK_N W MODELTYPE=RLGC N=1
+ Lo=
+ 3.32029740e-07
+ Co=
+ 1.03489020e-10
+ Ro=
+ 3.96831067e+00
+ Go=
+ 0.00000000e+00
+ Rs=
+ 1.55902417e-03
+ Gd=
+ 2.04067990e-11

.Model Wmodel_Trace446_Auto_123::HDMI_CLK_N W MODELTYPE=RLGC N=2
+ Lo=
+ 3.30731671e-07
+ 4.23978481e-08 3.30731671e-07
+ Co=
+ 1.03813305e-10
+ -4.56100645e-12 1.03813305e-10
+ Ro=
+ 3.96831067e+00
+ 0.00000000e+00 3.96831067e+00
+ Go=
+ 0.00000000e+00
+ -0.00000000e+00 0.00000000e+00
+ Rs=
+ 1.55902417e-03
+ -0.00000000e+00 1.55902417e-03
+ Gd=
+ 2.03825852e-11
+ -1.79165192e-13 2.03825852e-11

.Model Wmodel_Trace446_Auto_124::HDMI_CLK_N W MODELTYPE=RLGC N=1
+ Lo=
+ 3.32029740e-07
+ Co=
+ 1.03489020e-10
+ Ro=
+ 3.96831067e+00
+ Go=
+ 0.00000000e+00
+ Rs=
+ 1.55902417e-03
+ Gd=
+ 2.04067990e-11

.Model Wmodel_Trace447::HDMI_CLK_N W MODELTYPE=RLGC N=1
+ Lo=
+ 3.32029740e-07
+ Co=
+ 1.03489020e-10
+ Ro=
+ 3.96831067e+00
+ Go=
+ 0.00000000e+00
+ Rs=
+ 1.55902417e-03
+ Gd=
+ 2.04067990e-11

.Model Wmodel_Trace449::HDMI_CLK_N W MODELTYPE=RLGC N=1
+ Lo=
+ 3.32029740e-07
+ Co=
+ 1.03489020e-10
+ Ro=
+ 3.96831067e+00
+ Go=
+ 0.00000000e+00
+ Rs=
+ 1.55902417e-03
+ Gd=
+ 2.04067990e-11

.Model Wmodel_Trace449_Auto_125::HDMI_CLK_N W MODELTYPE=RLGC N=2
+ Lo=
+ 3.30749237e-07
+ 4.21547735e-08 3.30749237e-07
+ Co=
+ 1.03807608e-10
+ -4.51977154e-12 1.03807608e-10
+ Ro=
+ 3.96831067e+00
+ 0.00000000e+00 3.96831067e+00
+ Go=
+ 0.00000000e+00
+ -0.00000000e+00 0.00000000e+00
+ Rs=
+ 1.55902417e-03
+ -0.00000000e+00 1.55902417e-03
+ Gd=
+ 2.03827288e-11
+ -1.75018480e-13 2.03827288e-11

.Model Wmodel_Trace450::HDMI_CLK_N W MODELTYPE=RLGC N=1
+ Lo=
+ 3.32029740e-07
+ Co=
+ 1.03489020e-10
+ Ro=
+ 3.96831067e+00
+ Go=
+ 0.00000000e+00
+ Rs=
+ 1.55902417e-03
+ Gd=
+ 2.04067990e-11
