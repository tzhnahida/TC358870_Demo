*Wmodel Definition*
*TraceModel Definition*

.Model Wmodel_Trace166::HDMI_DATA1_P W MODELTYPE=RLGC N=1
+ Lo=
+ 3.32029740e-07
+ Co=
+ 1.03489020e-10
+ Ro=
+ 3.96831067e+00
+ Go=
+ 0.00000000e+00
+ Rs=
+ 1.55902417e-03
+ Gd=
+ 2.04067990e-11

.Model Wmodel_Trace170::HDMI_DATA1_P W MODELTYPE=RLGC N=1
+ Lo=
+ 3.32029740e-07
+ Co=
+ 1.03489020e-10
+ Ro=
+ 3.96831067e+00
+ Go=
+ 0.00000000e+00
+ Rs=
+ 1.55902417e-03
+ Gd=
+ 2.04067990e-11

.Model Wmodel_Trace172_Auto_90::HDMI_DATA1_P W MODELTYPE=RLGC N=1
+ Lo=
+ 3.32029740e-07
+ Co=
+ 1.03489020e-10
+ Ro=
+ 3.96831067e+00
+ Go=
+ 0.00000000e+00
+ Rs=
+ 1.55902417e-03
+ Gd=
+ 2.04067990e-11

.Model Wmodel_Trace215::HDMI_DATA1_P W MODELTYPE=RLGC N=1
+ Lo=
+ 3.32029740e-07
+ Co=
+ 1.03489020e-10
+ Ro=
+ 3.96831067e+00
+ Go=
+ 0.00000000e+00
+ Rs=
+ 1.55902417e-03
+ Gd=
+ 2.04067990e-11

.Model Wmodel_Trace217_Auto_92::HDMI_DATA1_P W MODELTYPE=RLGC N=1
+ Lo=
+ 3.32029740e-07
+ Co=
+ 1.03489020e-10
+ Ro=
+ 3.96831067e+00
+ Go=
+ 0.00000000e+00
+ Rs=
+ 1.55902417e-03
+ Gd=
+ 2.04067990e-11

.Model Wmodel_Trace219::HDMI_DATA1_P W MODELTYPE=RLGC N=1
+ Lo=
+ 3.32029740e-07
+ Co=
+ 1.03489020e-10
+ Ro=
+ 3.96831067e+00
+ Go=
+ 0.00000000e+00
+ Rs=
+ 1.55902417e-03
+ Gd=
+ 2.04067990e-11

.Model Wmodel_Trace221::HDMI_DATA1_P W MODELTYPE=RLGC N=1
+ Lo=
+ 3.32029740e-07
+ Co=
+ 1.03489020e-10
+ Ro=
+ 3.96831067e+00
+ Go=
+ 0.00000000e+00
+ Rs=
+ 1.55902417e-03
+ Gd=
+ 2.04067990e-11

.Model Wmodel_Trace221_Auto_94::HDMI_DATA1_P W MODELTYPE=RLGC N=1
+ Lo=
+ 3.32029740e-07
+ Co=
+ 1.03489020e-10
+ Ro=
+ 3.96831067e+00
+ Go=
+ 0.00000000e+00
+ Rs=
+ 1.55902417e-03
+ Gd=
+ 2.04067990e-11

.Model Wmodel_Trace223::HDMI_DATA1_P W MODELTYPE=RLGC N=1
+ Lo=
+ 3.32029740e-07
+ Co=
+ 1.03489020e-10
+ Ro=
+ 3.96831067e+00
+ Go=
+ 0.00000000e+00
+ Rs=
+ 1.55902417e-03
+ Gd=
+ 2.04067990e-11

.Model Wmodel_Trace348::HDMI_DATA1_N W MODELTYPE=RLGC N=1
+ Lo=
+ 3.32029740e-07
+ Co=
+ 1.03489020e-10
+ Ro=
+ 3.96831067e+00
+ Go=
+ 0.00000000e+00
+ Rs=
+ 1.55902417e-03
+ Gd=
+ 2.04067990e-11

.Model Wmodel_Trace351::HDMI_DATA1_N W MODELTYPE=RLGC N=1
+ Lo=
+ 3.32029740e-07
+ Co=
+ 1.03489020e-10
+ Ro=
+ 3.96831067e+00
+ Go=
+ 0.00000000e+00
+ Rs=
+ 1.55902417e-03
+ Gd=
+ 2.04067990e-11

.Model Wmodel_Trace353::HDMI_DATA1_N W MODELTYPE=RLGC N=1
+ Lo=
+ 3.32029740e-07
+ Co=
+ 1.03489020e-10
+ Ro=
+ 3.96831067e+00
+ Go=
+ 0.00000000e+00
+ Rs=
+ 1.55902417e-03
+ Gd=
+ 2.04067990e-11

.Model Wmodel_Trace353_Auto_97::HDMI_DATA1_N W MODELTYPE=RLGC N=3
+ Lo=
+ 3.30686195e-07
+ 4.19541595e-08 3.29807727e-07
+ 1.10688860e-08 3.69094617e-08 3.31017425e-07
+ Co=
+ 1.03812940e-10
+ -4.49471166e-12 1.04020991e-10
+ -5.12646383e-13 -3.67497436e-12 1.03710652e-10
+ Ro=
+ 3.96831067e+00
+ 0.00000000e+00 3.96831067e+00
+ 0.00000000e+00 0.00000000e+00 3.96831067e+00
+ Go=
+ 0.00000000e+00
+ -0.00000000e+00 0.00000000e+00
+ -0.00000000e+00 -0.00000000e+00 0.00000000e+00
+ Rs=
+ 1.55902417e-03
+ -0.00000000e+00 1.55902417e-03
+ -0.00000000e+00 -0.00000000e+00 1.55902417e-03
+ Gd=
+ 2.03820670e-11
+ -1.79166693e-13 2.03631384e-11
+ -0.00000000e+00 -1.02648202e-13 2.03856825e-11

.Model Wmodel_Trace353_Auto_98::HDMI_DATA1_N W MODELTYPE=RLGC N=2
+ Lo=
+ 3.30747262e-07
+ 4.21821942e-08 3.30747262e-07
+ Co=
+ 1.03808247e-10
+ -4.52441508e-12 1.03808247e-10
+ Ro=
+ 3.96831067e+00
+ 0.00000000e+00 3.96831067e+00
+ Go=
+ 0.00000000e+00
+ -0.00000000e+00 0.00000000e+00
+ Rs=
+ 1.55902417e-03
+ -0.00000000e+00 1.55902417e-03
+ Gd=
+ 2.03827124e-11
+ -1.75484369e-13 2.03827124e-11

.Model Wmodel_Trace353_Auto_99::HDMI_DATA1_N W MODELTYPE=RLGC N=4
+ Lo=
+ 3.30668353e-07
+ 4.18943374e-08 3.29561773e-07
+ 1.14697486e-08 3.94788554e-08 3.29563352e-07
+ 5.11162797e-09 1.14660078e-08 4.18716314e-08 3.30670042e-07
+ Co=
+ 1.03814199e-10
+ -4.48820607e-12 1.04079972e-10
+ -5.14278466e-13 -4.09357449e-12 1.04079448e-10
+ -2.27296254e-13 -5.14148852e-13 -4.48435260e-12 1.03813666e-10
+ Ro=
+ 3.96831067e+00
+ 0.00000000e+00 3.96831067e+00
+ 0.00000000e+00 0.00000000e+00 3.96831067e+00
+ 0.00000000e+00 0.00000000e+00 0.00000000e+00 3.96831067e+00
+ Go=
+ 0.00000000e+00
+ -0.00000000e+00 0.00000000e+00
+ -0.00000000e+00 -0.00000000e+00 0.00000000e+00
+ -0.00000000e+00 -0.00000000e+00 -0.00000000e+00 0.00000000e+00
+ Rs=
+ 1.55902417e-03
+ -0.00000000e+00 1.55902417e-03
+ -0.00000000e+00 -0.00000000e+00 1.55902417e-03
+ -0.00000000e+00 -0.00000000e+00 -0.00000000e+00 1.55902417e-03
+ Gd=
+ 2.03819073e-11
+ -1.79821273e-13 2.03604367e-11
+ -0.00000000e+00 -1.48683189e-13 2.03604492e-11
+ -0.00000000e+00 -0.00000000e+00 -1.79433317e-13 2.03819212e-11

.Model Wmodel_Trace355::HDMI_DATA1_N W MODELTYPE=RLGC N=1
+ Lo=
+ 3.32029740e-07
+ Co=
+ 1.03489020e-10
+ Ro=
+ 3.96831067e+00
+ Go=
+ 0.00000000e+00
+ Rs=
+ 1.55902417e-03
+ Gd=
+ 2.04067990e-11

.Model Wmodel_Trace357::HDMI_DATA1_N W MODELTYPE=RLGC N=1
+ Lo=
+ 3.32029740e-07
+ Co=
+ 1.03489020e-10
+ Ro=
+ 3.96831067e+00
+ Go=
+ 0.00000000e+00
+ Rs=
+ 1.55902417e-03
+ Gd=
+ 2.04067990e-11

.Model Wmodel_Trace357_Auto_89::HDMI_DATA1_N W MODELTYPE=RLGC N=2
+ Lo=
+ 3.30784317e-07
+ 4.16632978e-08 3.30784317e-07
+ Co=
+ 1.03796308e-10
+ -4.43689152e-12 1.03796308e-10
+ Ro=
+ 3.96831067e+00
+ 0.00000000e+00 3.96831067e+00
+ Go=
+ 0.00000000e+00
+ -0.00000000e+00 0.00000000e+00
+ Rs=
+ 1.55902417e-03
+ -0.00000000e+00 1.55902417e-03
+ Gd=
+ 2.03830298e-11
+ -1.66749822e-13 2.03830298e-11

.Model Wmodel_Trace377::HDMI_DATA1_N W MODELTYPE=RLGC N=1
+ Lo=
+ 3.32029740e-07
+ Co=
+ 1.03489020e-10
+ Ro=
+ 3.96831067e+00
+ Go=
+ 0.00000000e+00
+ Rs=
+ 1.55902417e-03
+ Gd=
+ 2.04067990e-11

.Model Wmodel_Trace379::HDMI_DATA1_N W MODELTYPE=RLGC N=1
+ Lo=
+ 3.32029740e-07
+ Co=
+ 1.03489020e-10
+ Ro=
+ 3.96831067e+00
+ Go=
+ 0.00000000e+00
+ Rs=
+ 1.55902417e-03
+ Gd=
+ 2.04067990e-11

.Model Wmodel_Trace379_Auto_91::HDMI_DATA1_N W MODELTYPE=RLGC N=2
+ Lo=
+ 3.30797598e-07
+ 4.14750767e-08 3.30797598e-07
+ Co=
+ 1.03792058e-10
+ -4.40532628e-12 1.03792058e-10
+ Ro=
+ 3.96831067e+00
+ 0.00000000e+00 3.96831067e+00
+ Go=
+ 0.00000000e+00
+ -0.00000000e+00 0.00000000e+00
+ Rs=
+ 1.55902417e-03
+ -0.00000000e+00 1.55902417e-03
+ Gd=
+ 2.03831488e-11
+ -1.63624287e-13 2.03831488e-11

.Model Wmodel_Trace381::HDMI_DATA1_N W MODELTYPE=RLGC N=1
+ Lo=
+ 3.32029740e-07
+ Co=
+ 1.03489020e-10
+ Ro=
+ 3.96831067e+00
+ Go=
+ 0.00000000e+00
+ Rs=
+ 1.55902417e-03
+ Gd=
+ 2.04067990e-11

.Model Wmodel_Trace383::HDMI_DATA1_N W MODELTYPE=RLGC N=2
+ Lo=
+ 3.30739043e-07
+ 4.22960763e-08 3.30739043e-07
+ Co=
+ 1.03810911e-10
+ -4.54372237e-12 1.03810911e-10
+ Ro=
+ 3.96831067e+00
+ 0.00000000e+00 3.96831067e+00
+ Go=
+ 0.00000000e+00
+ -0.00000000e+00 0.00000000e+00
+ Rs=
+ 1.55902417e-03
+ -0.00000000e+00 1.55902417e-03
+ Gd=
+ 2.03826449e-11
+ -1.77424428e-13 2.03826449e-11

.Model Wmodel_Trace391::HDMI_DATA1_N W MODELTYPE=RLGC N=1
+ Lo=
+ 3.32029740e-07
+ Co=
+ 1.03489020e-10
+ Ro=
+ 3.96831067e+00
+ Go=
+ 0.00000000e+00
+ Rs=
+ 1.55902417e-03
+ Gd=
+ 2.04067990e-11

.Model Wmodel_Trace44::HDMI_DATA2_N W MODELTYPE=RLGC N=1
+ Lo=
+ 3.32029740e-07
+ Co=
+ 1.03489020e-10
+ Ro=
+ 3.96831067e+00
+ Go=
+ 0.00000000e+00
+ Rs=
+ 1.55902417e-03
+ Gd=
+ 2.04067990e-11

.Model Wmodel_Trace47::HDMI_DATA2_N W MODELTYPE=RLGC N=1
+ Lo=
+ 3.32029740e-07
+ Co=
+ 1.03489020e-10
+ Ro=
+ 3.96831067e+00
+ Go=
+ 0.00000000e+00
+ Rs=
+ 1.55902417e-03
+ Gd=
+ 2.04067990e-11

.Model Wmodel_Trace49::HDMI_DATA2_N W MODELTYPE=RLGC N=1
+ Lo=
+ 3.32029740e-07
+ Co=
+ 1.03489020e-10
+ Ro=
+ 3.96831067e+00
+ Go=
+ 0.00000000e+00
+ Rs=
+ 1.55902417e-03
+ Gd=
+ 2.04067990e-11

.Model Wmodel_Trace51::HDMI_DATA2_N W MODELTYPE=RLGC N=1
+ Lo=
+ 3.32029740e-07
+ Co=
+ 1.03489020e-10
+ Ro=
+ 3.96831067e+00
+ Go=
+ 0.00000000e+00
+ Rs=
+ 1.55902417e-03
+ Gd=
+ 2.04067990e-11

.Model Wmodel_Trace53::HDMI_DATA2_N W MODELTYPE=RLGC N=1
+ Lo=
+ 3.32029740e-07
+ Co=
+ 1.03489020e-10
+ Ro=
+ 3.96831067e+00
+ Go=
+ 0.00000000e+00
+ Rs=
+ 1.55902417e-03
+ Gd=
+ 2.04067990e-11

.Model Wmodel_Trace53_Auto_362::HDMI_DATA2_N W MODELTYPE=RLGC N=2
+ Lo=
+ 3.30732748e-07
+ 4.23829977e-08 3.30732748e-07
+ Co=
+ 1.03812955e-10
+ -4.55848262e-12 1.03812955e-10
+ Ro=
+ 3.96831067e+00
+ 0.00000000e+00 3.96831067e+00
+ Go=
+ 0.00000000e+00
+ -0.00000000e+00 0.00000000e+00
+ Rs=
+ 1.55902417e-03
+ -0.00000000e+00 1.55902417e-03
+ Gd=
+ 2.03825939e-11
+ -1.78910770e-13 2.03825939e-11

.Model Wmodel_Trace53_Auto_365::HDMI_DATA2_N W MODELTYPE=RLGC N=2
+ Lo=
+ 3.30740212e-07
+ 4.22798944e-08 3.30740212e-07
+ Co=
+ 1.03810531e-10
+ -4.54097678e-12 1.03810531e-10
+ Ro=
+ 3.96831067e+00
+ 0.00000000e+00 3.96831067e+00
+ Go=
+ 0.00000000e+00
+ -0.00000000e+00 0.00000000e+00
+ Rs=
+ 1.55902417e-03
+ -0.00000000e+00 1.55902417e-03
+ Gd=
+ 2.03826544e-11
+ -1.77148253e-13 2.03826544e-11

.Model Wmodel_Trace53_Auto_366::HDMI_DATA2_N W MODELTYPE=RLGC N=1
+ Lo=
+ 3.32029740e-07
+ Co=
+ 1.03489020e-10
+ Ro=
+ 3.96831067e+00
+ Go=
+ 0.00000000e+00
+ Rs=
+ 1.55902417e-03
+ Gd=
+ 2.04067990e-11

.Model Wmodel_Trace55::HDMI_DATA2_N W MODELTYPE=RLGC N=1
+ Lo=
+ 3.32029740e-07
+ Co=
+ 1.03489020e-10
+ Ro=
+ 3.96831067e+00
+ Go=
+ 0.00000000e+00
+ Rs=
+ 1.55902417e-03
+ Gd=
+ 2.04067990e-11

.Model Wmodel_Trace57::HDMI_DATA2_N W MODELTYPE=RLGC N=2
+ Lo=
+ 3.30747262e-07
+ 4.21821942e-08 3.30747262e-07
+ Co=
+ 1.03808247e-10
+ -4.52441508e-12 1.03808247e-10
+ Ro=
+ 3.96831067e+00
+ 0.00000000e+00 3.96831067e+00
+ Go=
+ 0.00000000e+00
+ -0.00000000e+00 0.00000000e+00
+ Rs=
+ 1.55902417e-03
+ -0.00000000e+00 1.55902417e-03
+ Gd=
+ 2.03827124e-11
+ -1.75484369e-13 2.03827124e-11

.Model Wmodel_Trace59::HDMI_DATA2_N W MODELTYPE=RLGC N=1
+ Lo=
+ 3.32029740e-07
+ Co=
+ 1.03489020e-10
+ Ro=
+ 3.96831067e+00
+ Go=
+ 0.00000000e+00
+ Rs=
+ 1.55902417e-03
+ Gd=
+ 2.04067990e-11

.Model Wmodel_Trace61::HDMI_DATA2_P W MODELTYPE=RLGC N=1
+ Lo=
+ 3.32029740e-07
+ Co=
+ 1.03489020e-10
+ Ro=
+ 3.96831067e+00
+ Go=
+ 0.00000000e+00
+ Rs=
+ 1.55902417e-03
+ Gd=
+ 2.04067990e-11

.Model Wmodel_Trace63::HDMI_DATA2_P W MODELTYPE=RLGC N=1
+ Lo=
+ 3.32029740e-07
+ Co=
+ 1.03489020e-10
+ Ro=
+ 3.96831067e+00
+ Go=
+ 0.00000000e+00
+ Rs=
+ 1.55902417e-03
+ Gd=
+ 2.04067990e-11

.Model Wmodel_Trace86::HDMI_DATA2_P W MODELTYPE=RLGC N=1
+ Lo=
+ 3.32029740e-07
+ Co=
+ 1.03489020e-10
+ Ro=
+ 3.96831067e+00
+ Go=
+ 0.00000000e+00
+ Rs=
+ 1.55902417e-03
+ Gd=
+ 2.04067990e-11

.Model Wmodel_Trace88::HDMI_DATA2_P W MODELTYPE=RLGC N=1
+ Lo=
+ 3.32029740e-07
+ Co=
+ 1.03489020e-10
+ Ro=
+ 3.96831067e+00
+ Go=
+ 0.00000000e+00
+ Rs=
+ 1.55902417e-03
+ Gd=
+ 2.04067990e-11

.Model Wmodel_Trace88_Auto_363::HDMI_DATA2_P W MODELTYPE=RLGC N=1
+ Lo=
+ 3.32029740e-07
+ Co=
+ 1.03489020e-10
+ Ro=
+ 3.96831067e+00
+ Go=
+ 0.00000000e+00
+ Rs=
+ 1.55902417e-03
+ Gd=
+ 2.04067990e-11

.Model Wmodel_Trace90::HDMI_DATA2_P W MODELTYPE=RLGC N=1
+ Lo=
+ 3.32029740e-07
+ Co=
+ 1.03489020e-10
+ Ro=
+ 3.96831067e+00
+ Go=
+ 0.00000000e+00
+ Rs=
+ 1.55902417e-03
+ Gd=
+ 2.04067990e-11

.Model Wmodel_Trace92::HDMI_DATA2_P W MODELTYPE=RLGC N=1
+ Lo=
+ 3.32029740e-07
+ Co=
+ 1.03489020e-10
+ Ro=
+ 3.96831067e+00
+ Go=
+ 0.00000000e+00
+ Rs=
+ 1.55902417e-03
+ Gd=
+ 2.04067990e-11

.Model Wmodel_Trace94::HDMI_DATA2_P W MODELTYPE=RLGC N=1
+ Lo=
+ 3.32029740e-07
+ Co=
+ 1.03489020e-10
+ Ro=
+ 3.96831067e+00
+ Go=
+ 0.00000000e+00
+ Rs=
+ 1.55902417e-03
+ Gd=
+ 2.04067990e-11

.Model Wmodel_Trace97::HDMI_DATA2_P W MODELTYPE=RLGC N=1
+ Lo=
+ 3.32029740e-07
+ Co=
+ 1.03489020e-10
+ Ro=
+ 3.96831067e+00
+ Go=
+ 0.00000000e+00
+ Rs=
+ 1.55902417e-03
+ Gd=
+ 2.04067990e-11
