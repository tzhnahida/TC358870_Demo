*Wmodel Definition*
*TraceModel Definition*

.Model Wmodel_Trace1001_Auto_2880::MIPI_DSI1_DATA2_N W MODELTYPE=RLGC N=1
+ Lo=
+ 3.32029740e-07
+ Co=
+ 1.03489020e-10
+ Ro=
+ 3.96831067e+00
+ Go=
+ 0.00000000e+00
+ Rs=
+ 1.55902417e-03
+ Gd=
+ 2.04067990e-11

.Model Wmodel_Trace1010::MIPI_DSI1_DATA2_N W MODELTYPE=RLGC N=1
+ Lo=
+ 3.32029740e-07
+ Co=
+ 1.03489020e-10
+ Ro=
+ 3.96831067e+00
+ Go=
+ 0.00000000e+00
+ Rs=
+ 1.55902417e-03
+ Gd=
+ 2.04067990e-11

.Model Wmodel_Trace1012_Auto_2895::MIPI_DSI1_DATA2_N W MODELTYPE=RLGC N=1
+ Lo=
+ 3.32029740e-07
+ Co=
+ 1.03489020e-10
+ Ro=
+ 3.96831067e+00
+ Go=
+ 0.00000000e+00
+ Rs=
+ 1.55902417e-03
+ Gd=
+ 2.04067990e-11

.Model Wmodel_Trace1014::MIPI_DSI1_DATA2_N W MODELTYPE=RLGC N=1
+ Lo=
+ 3.32029740e-07
+ Co=
+ 1.03489020e-10
+ Ro=
+ 3.96831067e+00
+ Go=
+ 0.00000000e+00
+ Rs=
+ 1.55902417e-03
+ Gd=
+ 2.04067990e-11

.Model Wmodel_Trace1024::MIPI_DSI1_DATA2_N W MODELTYPE=RLGC N=2
+ Lo=
+ 3.30748548e-07
+ 4.21643405e-08 3.30748548e-07
+ Co=
+ 1.03807831e-10
+ -4.52139143e-12 1.03807831e-10
+ Ro=
+ 3.96831067e+00
+ 0.00000000e+00 3.96831067e+00
+ Go=
+ 0.00000000e+00
+ -0.00000000e+00 0.00000000e+00
+ Rs=
+ 1.55902417e-03
+ -0.00000000e+00 1.55902417e-03
+ Gd=
+ 2.03827231e-11
+ -1.75180973e-13 2.03827231e-11

.Model Wmodel_Trace1024_Auto_2887::MIPI_DSI1_DATA2_N W MODELTYPE=RLGC N=8
+ Lo=
+ 3.30659850e-07
+ 4.18420962e-08 3.29400569e-07
+ 1.18136088e-08 4.15538169e-08 3.29362789e-07
+ 5.17753113e-09 1.17611110e-08 4.17020244e-08 3.30182737e-07
+ 2.47278566e-09 4.21588952e-09 8.83147567e-09 2.62285483e-08 3.30146570e-07
+ 1.61683658e-09 2.45446604e-09 4.23364287e-09 8.88025339e-09 4.21465131e-08 3.29258685e-07
+ 1.14408454e-09 1.60950136e-09 2.46939055e-09 4.26571330e-09 1.19935227e-08 4.24655955e-08 3.29296365e-07
+ 8.59850741e-10 1.14650820e-09 1.62876185e-09 2.50228562e-09 5.26787043e-09 1.20471705e-08 4.22908901e-08 3.30622415e-07
+ Co=
+ 1.03814480e-10
+ -4.48101291e-12 1.04126982e-10
+ -5.24379587e-13 -4.44260821e-12 1.04130026e-10
+ -2.26467292e-13 -5.17473258e-13 -4.46439984e-12 1.03897853e-10
+ -1.12394046e-13 -1.86611767e-13 -4.06752563e-13 -2.18308652e-12 1.03908784e-10
+ -7.08514756e-14 -1.03545317e-13 -1.78887759e-13 -4.08125174e-13 -4.54079634e-12 1.04162942e-10
+ -5.03911450e-14 -6.80322549e-14 -1.04071642e-13 -1.88177081e-13 -5.24425178e-13 -4.59948758e-12 1.04159990e-10
+ -3.96697021e-14 -5.05894148e-14 -7.14426655e-14 -1.13596399e-13 -2.29444117e-13 -5.31389426e-13 -4.55808937e-12 1.03825609e-10
+ Ro=
+ 3.96831067e+00
+ 0.00000000e+00 3.96831067e+00
+ 0.00000000e+00 0.00000000e+00 3.96831067e+00
+ 0.00000000e+00 0.00000000e+00 0.00000000e+00 3.96831067e+00
+ 0.00000000e+00 0.00000000e+00 0.00000000e+00 0.00000000e+00 3.96831067e+00
+ 0.00000000e+00 0.00000000e+00 0.00000000e+00 0.00000000e+00 0.00000000e+00 3.96831067e+00
+ 0.00000000e+00 0.00000000e+00 0.00000000e+00 0.00000000e+00 0.00000000e+00 0.00000000e+00 3.96831067e+00
+ 0.00000000e+00 0.00000000e+00 0.00000000e+00 0.00000000e+00 0.00000000e+00 0.00000000e+00 0.00000000e+00 3.96831067e+00
+ Go=
+ 0.00000000e+00
+ -0.00000000e+00 0.00000000e+00
+ -0.00000000e+00 -0.00000000e+00 0.00000000e+00
+ -0.00000000e+00 -0.00000000e+00 -0.00000000e+00 0.00000000e+00
+ -0.00000000e+00 -0.00000000e+00 -0.00000000e+00 -0.00000000e+00 0.00000000e+00
+ -0.00000000e+00 -0.00000000e+00 -0.00000000e+00 -0.00000000e+00 -0.00000000e+00 0.00000000e+00
+ -0.00000000e+00 -0.00000000e+00 -0.00000000e+00 -0.00000000e+00 -0.00000000e+00 -0.00000000e+00 0.00000000e+00
+ -0.00000000e+00 -0.00000000e+00 -0.00000000e+00 -0.00000000e+00 -0.00000000e+00 -0.00000000e+00 -0.00000000e+00 0.00000000e+00
+ Rs=
+ 1.55902417e-03
+ -0.00000000e+00 1.55902417e-03
+ -0.00000000e+00 -0.00000000e+00 1.55902417e-03
+ -0.00000000e+00 -0.00000000e+00 -0.00000000e+00 1.55902417e-03
+ -0.00000000e+00 -0.00000000e+00 -0.00000000e+00 -0.00000000e+00 1.55902417e-03
+ -0.00000000e+00 -0.00000000e+00 -0.00000000e+00 -0.00000000e+00 -0.00000000e+00 1.55902417e-03
+ -0.00000000e+00 -0.00000000e+00 -0.00000000e+00 -0.00000000e+00 -0.00000000e+00 -0.00000000e+00 1.55902417e-03
+ -0.00000000e+00 -0.00000000e+00 -0.00000000e+00 -0.00000000e+00 -0.00000000e+00 -0.00000000e+00 -0.00000000e+00 1.55902417e-03
+ Gd=
+ 2.03818287e-11
+ -1.79895809e-13 2.03589747e-11
+ -0.00000000e+00 -1.83631593e-13 2.03585529e-11
+ -0.00000000e+00 -0.00000000e+00 -1.82218005e-13 2.03706772e-11
+ -0.00000000e+00 -0.00000000e+00 -0.00000000e+00 -4.56380380e-16 2.03704056e-11
+ -0.00000000e+00 -0.00000000e+00 -0.00000000e+00 -0.00000000e+00 -1.90243864e-13 2.03577946e-11
+ -0.00000000e+00 -0.00000000e+00 -0.00000000e+00 -0.00000000e+00 -0.00000000e+00 -1.99914822e-13 2.03582138e-11
+ -0.00000000e+00 -0.00000000e+00 -0.00000000e+00 -0.00000000e+00 -0.00000000e+00 -0.00000000e+00 -1.87990216e-13 2.03815391e-11

.Model Wmodel_Trace1024_Auto_2896::MIPI_DSI1_DATA2_N W MODELTYPE=RLGC N=4
+ Lo=
+ 3.30626938e-07
+ 4.22996926e-08 3.29308872e-07
+ 1.20611740e-08 4.24858406e-08 3.29309199e-07
+ 5.30623171e-09 1.20603568e-08 4.22950305e-08 3.30627292e-07
+ Co=
+ 1.03825206e-10
+ -4.55898159e-12 1.04158885e-10
+ -5.32669646e-13 -4.60080799e-12 1.04158775e-10
+ -2.34529497e-13 -5.32641923e-13 -4.55818423e-12 1.03825094e-10
+ Ro=
+ 3.96831067e+00
+ 0.00000000e+00 3.96831067e+00
+ 0.00000000e+00 0.00000000e+00 3.96831067e+00
+ 0.00000000e+00 0.00000000e+00 0.00000000e+00 3.96831067e+00
+ Go=
+ 0.00000000e+00
+ -0.00000000e+00 0.00000000e+00
+ -0.00000000e+00 -0.00000000e+00 0.00000000e+00
+ -0.00000000e+00 -0.00000000e+00 -0.00000000e+00 0.00000000e+00
+ Rs=
+ 1.55902417e-03
+ -0.00000000e+00 1.55902417e-03
+ -0.00000000e+00 -0.00000000e+00 1.55902417e-03
+ -0.00000000e+00 -0.00000000e+00 -0.00000000e+00 1.55902417e-03
+ Gd=
+ 2.03816011e-11
+ -1.87918306e-13 2.03583559e-11
+ -0.00000000e+00 -1.99563417e-13 2.03583583e-11
+ -0.00000000e+00 -0.00000000e+00 -1.87837216e-13 2.03816038e-11

.Model Wmodel_Trace1024_Auto_2897::MIPI_DSI1_DATA2_N W MODELTYPE=RLGC N=1
+ Lo=
+ 3.32029740e-07
+ Co=
+ 1.03489020e-10
+ Ro=
+ 3.96831067e+00
+ Go=
+ 0.00000000e+00
+ Rs=
+ 1.55902417e-03
+ Gd=
+ 2.04067990e-11

.Model Wmodel_Trace1028::MIPI_DSI1_DATA2_N W MODELTYPE=RLGC N=1
+ Lo=
+ 3.32029740e-07
+ Co=
+ 1.03489020e-10
+ Ro=
+ 3.96831067e+00
+ Go=
+ 0.00000000e+00
+ Rs=
+ 1.55902417e-03
+ Gd=
+ 2.04067990e-11

.Model Wmodel_Trace1032::MIPI_DSI1_DATA2_N W MODELTYPE=RLGC N=1
+ Lo=
+ 3.32029740e-07
+ Co=
+ 1.03489020e-10
+ Ro=
+ 3.96831067e+00
+ Go=
+ 0.00000000e+00
+ Rs=
+ 1.55902417e-03
+ Gd=
+ 2.04067990e-11

.Model Wmodel_Trace1034::MIPI_DSI1_DATA2_N W MODELTYPE=RLGC N=1
+ Lo=
+ 3.32029740e-07
+ Co=
+ 1.03489020e-10
+ Ro=
+ 3.96831067e+00
+ Go=
+ 0.00000000e+00
+ Rs=
+ 1.55902417e-03
+ Gd=
+ 2.04067990e-11

.Model Wmodel_Trace1034_Auto_2130::MIPI_DSI1_DATA2_N W MODELTYPE=RLGC N=1
+ Lo=
+ 3.32029740e-07
+ Co=
+ 1.03489020e-10
+ Ro=
+ 3.96831067e+00
+ Go=
+ 0.00000000e+00
+ Rs=
+ 1.55902417e-03
+ Gd=
+ 2.04067990e-11

.Model Wmodel_Trace1036::MIPI_DSI1_DATA2_N W MODELTYPE=RLGC N=1
+ Lo=
+ 3.32029740e-07
+ Co=
+ 1.03489020e-10
+ Ro=
+ 3.96831067e+00
+ Go=
+ 0.00000000e+00
+ Rs=
+ 1.55902417e-03
+ Gd=
+ 2.04067990e-11

.Model Wmodel_Trace1037::MIPI_DSI1_DATA2_N W MODELTYPE=RLGC N=1
+ Lo=
+ 3.32029740e-07
+ Co=
+ 1.03489020e-10
+ Ro=
+ 3.96831067e+00
+ Go=
+ 0.00000000e+00
+ Rs=
+ 1.55902417e-03
+ Gd=
+ 2.04067990e-11

.Model Wmodel_Trace1042::MIPI_DSI1_DATA2_N W MODELTYPE=RLGC N=1
+ Lo=
+ 3.32029740e-07
+ Co=
+ 1.03489020e-10
+ Ro=
+ 3.96831067e+00
+ Go=
+ 0.00000000e+00
+ Rs=
+ 1.55902417e-03
+ Gd=
+ 2.04067990e-11

.Model Wmodel_Trace1054::MIPI_DSI1_DATA2_N W MODELTYPE=RLGC N=1
+ Lo=
+ 3.32029740e-07
+ Co=
+ 1.03489020e-10
+ Ro=
+ 3.96831067e+00
+ Go=
+ 0.00000000e+00
+ Rs=
+ 1.55902417e-03
+ Gd=
+ 2.04067990e-11

.Model Wmodel_Trace1056::MIPI_DSI1_DATA2_N W MODELTYPE=RLGC N=2
+ Lo=
+ 3.31623831e-07
+ 2.58022981e-08 3.31623831e-07
+ Co=
+ 1.03563533e-10
+ -2.13842148e-12 1.03563533e-10
+ Ro=
+ 3.96831067e+00
+ 0.00000000e+00 3.96831067e+00
+ Go=
+ 0.00000000e+00
+ -0.00000000e+00 0.00000000e+00
+ Rs=
+ 1.55902417e-03
+ -0.00000000e+00 1.55902417e-03
+ Gd=
+ 2.03963397e-11
+ -0.00000000e+00 2.03963397e-11

.Model Wmodel_Trace1058::MIPI_DSI1_DATA2_N W MODELTYPE=RLGC N=1
+ Lo=
+ 3.32029740e-07
+ Co=
+ 1.03489020e-10
+ Ro=
+ 3.96831067e+00
+ Go=
+ 0.00000000e+00
+ Rs=
+ 1.55902417e-03
+ Gd=
+ 2.04067990e-11

.Model Wmodel_Trace1062::MIPI_DSI1_DATA2_N W MODELTYPE=RLGC N=1
+ Lo=
+ 8.24350330e-07
+ Co=
+ 3.67394016e-11
+ Ro=
+ 3.96831067e+00
+ Go=
+ 0.00000000e+00
+ Rs=
+ 1.02517469e-03
+ Gd=
+ 6.50321060e-12

.Model Wmodel_Trace1064::MIPI_DSI1_DATA2_N W MODELTYPE=RLGC N=1
+ Lo=
+ 3.32029740e-07
+ Co=
+ 1.03489020e-10
+ Ro=
+ 3.96831067e+00
+ Go=
+ 0.00000000e+00
+ Rs=
+ 1.55902417e-03
+ Gd=
+ 2.04067990e-11

.Model Wmodel_Trace1066#BP0::MIPI_DSI1_DATA2_N W MODELTYPE=RLGC N=1
+ Lo=
+ 3.32029740e-07
+ Co=
+ 1.03489020e-10
+ Ro=
+ 3.96831067e+00
+ Go=
+ 0.00000000e+00
+ Rs=
+ 1.55902417e-03
+ Gd=
+ 2.04067990e-11

.Model Wmodel_Trace1067#BP0::MIPI_DSI1_DATA2_N W MODELTYPE=RLGC N=1
+ Lo=
+ 8.24350330e-07
+ Co=
+ 3.67394016e-11
+ Ro=
+ 3.96831067e+00
+ Go=
+ 0.00000000e+00
+ Rs=
+ 1.02517469e-03
+ Gd=
+ 6.50321060e-12

.Model Wmodel_Trace1067#BP1::MIPI_DSI1_DATA2_N W MODELTYPE=RLGC N=1
+ Lo=
+ 3.32029740e-07
+ Co=
+ 1.03489020e-10
+ Ro=
+ 3.96831067e+00
+ Go=
+ 0.00000000e+00
+ Rs=
+ 1.55902417e-03
+ Gd=
+ 2.04067990e-11

.Model Wmodel_Trace1067#BP1_Auto_2473::MIPI_DSI1_DATA2_N W MODELTYPE=RLGC N=2
+ Lo=
+ 3.31589863e-07
+ 2.67149263e-08 3.31589863e-07
+ Co=
+ 1.03571227e-10
+ -2.24984707e-12 1.03571227e-10
+ Ro=
+ 3.96831067e+00
+ 0.00000000e+00 3.96831067e+00
+ Go=
+ 0.00000000e+00
+ -0.00000000e+00 0.00000000e+00
+ Rs=
+ 1.55902417e-03
+ -0.00000000e+00 1.55902417e-03
+ Gd=
+ 2.03955624e-11
+ -0.00000000e+00 2.03955624e-11

.Model Wmodel_Trace1067#BP1_Auto_2548::MIPI_DSI1_DATA2_N W MODELTYPE=RLGC N=2
+ Lo=
+ 3.31513115e-07
+ 2.86334703e-08 3.31513115e-07
+ Co=
+ 1.03589264e-10
+ -2.49269531e-12 1.03589264e-10
+ Ro=
+ 3.96831067e+00
+ 0.00000000e+00 3.96831067e+00
+ Go=
+ 0.00000000e+00
+ -0.00000000e+00 0.00000000e+00
+ Rs=
+ 1.55902417e-03
+ -0.00000000e+00 1.55902417e-03
+ Gd=
+ 2.03938807e-11
+ -6.48489357e-15 2.03938807e-11

.Model Wmodel_Trace1067#BP1_Auto_2551::MIPI_DSI1_DATA2_N W MODELTYPE=RLGC N=2
+ Lo=
+ 3.31496545e-07
+ 2.90250665e-08 3.31496545e-07
+ Co=
+ 1.03593272e-10
+ -2.54368631e-12 1.03593272e-10
+ Ro=
+ 3.96831067e+00
+ 0.00000000e+00 3.96831067e+00
+ Go=
+ 0.00000000e+00
+ -0.00000000e+00 0.00000000e+00
+ Rs=
+ 1.55902417e-03
+ -0.00000000e+00 1.55902417e-03
+ Gd=
+ 2.03935313e-11
+ -9.59644666e-15 2.03935313e-11

.Model Wmodel_Trace1067_Auto_2134::MIPI_DSI1_DATA2_N W MODELTYPE=RLGC N=1
+ Lo=
+ 3.32029740e-07
+ Co=
+ 1.03489020e-10
+ Ro=
+ 3.96831067e+00
+ Go=
+ 0.00000000e+00
+ Rs=
+ 1.55902417e-03
+ Gd=
+ 2.04067990e-11

.Model Wmodel_Trace1069::MIPI_DSI1_DATA2_N W MODELTYPE=RLGC N=1
+ Lo=
+ 3.32029740e-07
+ Co=
+ 1.03489020e-10
+ Ro=
+ 3.96831067e+00
+ Go=
+ 0.00000000e+00
+ Rs=
+ 1.55902417e-03
+ Gd=
+ 2.04067990e-11

.Model Wmodel_Trace1071::MIPI_DSI1_DATA2_N W MODELTYPE=RLGC N=1
+ Lo=
+ 3.32029740e-07
+ Co=
+ 1.03489020e-10
+ Ro=
+ 3.96831067e+00
+ Go=
+ 0.00000000e+00
+ Rs=
+ 1.55902417e-03
+ Gd=
+ 2.04067990e-11

.Model Wmodel_Trace1071_Auto_2530::MIPI_DSI1_DATA2_N W MODELTYPE=RLGC N=1
+ Lo=
+ 3.32029740e-07
+ Co=
+ 1.03489020e-10
+ Ro=
+ 3.96831067e+00
+ Go=
+ 0.00000000e+00
+ Rs=
+ 1.55902417e-03
+ Gd=
+ 2.04067990e-11

.Model Wmodel_Trace1080::MIPI_DSI1_DATA2_N W MODELTYPE=RLGC N=1
+ Lo=
+ 3.32029740e-07
+ Co=
+ 1.03489020e-10
+ Ro=
+ 3.96831067e+00
+ Go=
+ 0.00000000e+00
+ Rs=
+ 1.55902417e-03
+ Gd=
+ 2.04067990e-11

.Model Wmodel_Trace1082::MIPI_DSI1_DATA2_N W MODELTYPE=RLGC N=3
+ Lo=
+ 3.29382305e-07
+ 5.58399968e-08 3.28234015e-07
+ 1.41522904e-08 4.16757294e-08 3.30643200e-07
+ Co=
+ 1.04277970e-10
+ -7.11136566e-12 1.04581262e-10
+ -6.03695292e-13 -4.45740122e-12 1.03814363e-10
+ Ro=
+ 3.96831067e+00
+ 0.00000000e+00 3.96831067e+00
+ 0.00000000e+00 0.00000000e+00 3.96831067e+00
+ Go=
+ 0.00000000e+00
+ -0.00000000e+00 0.00000000e+00
+ -0.00000000e+00 -0.00000000e+00 0.00000000e+00
+ Rs=
+ 1.55902417e-03
+ -0.00000000e+00 1.55902417e-03
+ -0.00000000e+00 -0.00000000e+00 1.55902417e-03
+ Gd=
+ 2.03822696e-11
+ -4.77544768e-13 2.03606899e-11
+ -0.00000000e+00 -1.81123913e-13 2.03819078e-11

.Model Wmodel_Trace1091::MIPI_DSI1_DATA2_N W MODELTYPE=RLGC N=1
+ Lo=
+ 3.32029740e-07
+ Co=
+ 1.03489020e-10
+ Ro=
+ 3.96831067e+00
+ Go=
+ 0.00000000e+00
+ Rs=
+ 1.55902417e-03
+ Gd=
+ 2.04067990e-11

.Model Wmodel_Trace1102::MIPI_DSI1_DATA2_N W MODELTYPE=RLGC N=1
+ Lo=
+ 3.32029740e-07
+ Co=
+ 1.03489020e-10
+ Ro=
+ 3.96831067e+00
+ Go=
+ 0.00000000e+00
+ Rs=
+ 1.55902417e-03
+ Gd=
+ 2.04067990e-11

.Model Wmodel_Trace1104::MIPI_DSI1_DATA2_N W MODELTYPE=RLGC N=3
+ Lo=
+ 3.29382305e-07
+ 5.58399968e-08 3.28234015e-07
+ 1.41522904e-08 4.16757294e-08 3.30643200e-07
+ Co=
+ 1.04277970e-10
+ -7.11136566e-12 1.04581262e-10
+ -6.03695292e-13 -4.45740122e-12 1.03814363e-10
+ Ro=
+ 3.96831067e+00
+ 0.00000000e+00 3.96831067e+00
+ 0.00000000e+00 0.00000000e+00 3.96831067e+00
+ Go=
+ 0.00000000e+00
+ -0.00000000e+00 0.00000000e+00
+ -0.00000000e+00 -0.00000000e+00 0.00000000e+00
+ Rs=
+ 1.55902417e-03
+ -0.00000000e+00 1.55902417e-03
+ -0.00000000e+00 -0.00000000e+00 1.55902417e-03
+ Gd=
+ 2.03822696e-11
+ -4.77544768e-13 2.03606899e-11
+ -0.00000000e+00 -1.81123913e-13 2.03819078e-11

.Model Wmodel_Trace1113::MIPI_DSI1_DATA2_N W MODELTYPE=RLGC N=1
+ Lo=
+ 3.32029740e-07
+ Co=
+ 1.03489020e-10
+ Ro=
+ 3.96831067e+00
+ Go=
+ 0.00000000e+00
+ Rs=
+ 1.55902417e-03
+ Gd=
+ 2.04067990e-11

.Model Wmodel_Trace1124::MIPI_DSI1_DATA2_N W MODELTYPE=RLGC N=1
+ Lo=
+ 3.32029740e-07
+ Co=
+ 1.03489020e-10
+ Ro=
+ 3.96831067e+00
+ Go=
+ 0.00000000e+00
+ Rs=
+ 1.55902417e-03
+ Gd=
+ 2.04067990e-11

.Model Wmodel_Trace1126::MIPI_DSI1_DATA2_N W MODELTYPE=RLGC N=3
+ Lo=
+ 3.29382305e-07
+ 5.58399968e-08 3.28234015e-07
+ 1.41522904e-08 4.16757294e-08 3.30643200e-07
+ Co=
+ 1.04277970e-10
+ -7.11136566e-12 1.04581262e-10
+ -6.03695292e-13 -4.45740122e-12 1.03814363e-10
+ Ro=
+ 3.96831067e+00
+ 0.00000000e+00 3.96831067e+00
+ 0.00000000e+00 0.00000000e+00 3.96831067e+00
+ Go=
+ 0.00000000e+00
+ -0.00000000e+00 0.00000000e+00
+ -0.00000000e+00 -0.00000000e+00 0.00000000e+00
+ Rs=
+ 1.55902417e-03
+ -0.00000000e+00 1.55902417e-03
+ -0.00000000e+00 -0.00000000e+00 1.55902417e-03
+ Gd=
+ 2.03822696e-11
+ -4.77544768e-13 2.03606899e-11
+ -0.00000000e+00 -1.81123913e-13 2.03819078e-11

.Model Wmodel_Trace1135::MIPI_DSI1_DATA2_N W MODELTYPE=RLGC N=1
+ Lo=
+ 3.32029740e-07
+ Co=
+ 1.03489020e-10
+ Ro=
+ 3.96831067e+00
+ Go=
+ 0.00000000e+00
+ Rs=
+ 1.55902417e-03
+ Gd=
+ 2.04067990e-11

.Model Wmodel_Trace1146::MIPI_DSI1_DATA2_N W MODELTYPE=RLGC N=1
+ Lo=
+ 3.32029740e-07
+ Co=
+ 1.03489020e-10
+ Ro=
+ 3.96831067e+00
+ Go=
+ 0.00000000e+00
+ Rs=
+ 1.55902417e-03
+ Gd=
+ 2.04067990e-11

.Model Wmodel_Trace1148::MIPI_DSI1_DATA2_N W MODELTYPE=RLGC N=3
+ Lo=
+ 3.29382305e-07
+ 5.58399968e-08 3.28234015e-07
+ 1.41522904e-08 4.16757294e-08 3.30643200e-07
+ Co=
+ 1.04277970e-10
+ -7.11136566e-12 1.04581262e-10
+ -6.03695292e-13 -4.45740122e-12 1.03814363e-10
+ Ro=
+ 3.96831067e+00
+ 0.00000000e+00 3.96831067e+00
+ 0.00000000e+00 0.00000000e+00 3.96831067e+00
+ Go=
+ 0.00000000e+00
+ -0.00000000e+00 0.00000000e+00
+ -0.00000000e+00 -0.00000000e+00 0.00000000e+00
+ Rs=
+ 1.55902417e-03
+ -0.00000000e+00 1.55902417e-03
+ -0.00000000e+00 -0.00000000e+00 1.55902417e-03
+ Gd=
+ 2.03822696e-11
+ -4.77544768e-13 2.03606899e-11
+ -0.00000000e+00 -1.81123913e-13 2.03819078e-11

.Model Wmodel_Trace1157::MIPI_DSI1_DATA2_N W MODELTYPE=RLGC N=1
+ Lo=
+ 3.32029740e-07
+ Co=
+ 1.03489020e-10
+ Ro=
+ 3.96831067e+00
+ Go=
+ 0.00000000e+00
+ Rs=
+ 1.55902417e-03
+ Gd=
+ 2.04067990e-11

.Model Wmodel_Trace1168::MIPI_DSI1_DATA2_N W MODELTYPE=RLGC N=1
+ Lo=
+ 3.32029740e-07
+ Co=
+ 1.03489020e-10
+ Ro=
+ 3.96831067e+00
+ Go=
+ 0.00000000e+00
+ Rs=
+ 1.55902417e-03
+ Gd=
+ 2.04067990e-11

.Model Wmodel_Trace1170_Auto_2583::MIPI_DSI1_DATA2_N W MODELTYPE=RLGC N=1
+ Lo=
+ 3.32029740e-07
+ Co=
+ 1.03489020e-10
+ Ro=
+ 3.96831067e+00
+ Go=
+ 0.00000000e+00
+ Rs=
+ 1.55902417e-03
+ Gd=
+ 2.04067990e-11

.Model Wmodel_Trace1170_Auto_2588::MIPI_DSI1_DATA2_N W MODELTYPE=RLGC N=5
+ Lo=
+ 3.29323571e-07
+ 5.61233758e-08 3.28100289e-07
+ 1.40302129e-08 4.12719925e-08 3.28785101e-07
+ 6.14154495e-09 1.26926166e-08 4.78848981e-08 3.28840564e-07
+ 3.27833384e-09 5.45005706e-09 1.29381320e-08 4.22055933e-08 3.30608854e-07
+ Co=
+ 1.04294138e-10
+ -7.17609970e-12 1.04602158e-10
+ -5.82462489e-13 -4.40796807e-12 1.04307142e-10
+ -2.44290793e-13 -5.31088349e-13 -5.57790677e-12 1.04312719e-10
+ -1.39634583e-13 -2.29852409e-13 -5.57610728e-13 -4.54707889e-12 1.03826014e-10
+ Ro=
+ 3.96831067e+00
+ 0.00000000e+00 3.96831067e+00
+ 0.00000000e+00 0.00000000e+00 3.96831067e+00
+ 0.00000000e+00 0.00000000e+00 0.00000000e+00 3.96831067e+00
+ 0.00000000e+00 0.00000000e+00 0.00000000e+00 0.00000000e+00 3.96831067e+00
+ Go=
+ 0.00000000e+00
+ -0.00000000e+00 0.00000000e+00
+ -0.00000000e+00 -0.00000000e+00 0.00000000e+00
+ -0.00000000e+00 -0.00000000e+00 -0.00000000e+00 0.00000000e+00
+ -0.00000000e+00 -0.00000000e+00 -0.00000000e+00 -0.00000000e+00 0.00000000e+00
+ Rs=
+ 1.55902417e-03
+ -0.00000000e+00 1.55902417e-03
+ -0.00000000e+00 -0.00000000e+00 1.55902417e-03
+ -0.00000000e+00 -0.00000000e+00 -0.00000000e+00 1.55902417e-03
+ -0.00000000e+00 -0.00000000e+00 -0.00000000e+00 -0.00000000e+00 1.55902417e-03
+ Gd=
+ 2.03823659e-11
+ -4.86288844e-13 2.03602195e-11
+ -0.00000000e+00 -1.86196538e-13 2.03562437e-11
+ -0.00000000e+00 -0.00000000e+00 -3.05807100e-13 2.03565953e-11
+ -0.00000000e+00 -0.00000000e+00 -0.00000000e+00 -1.88558495e-13 2.03814981e-11

.Model Wmodel_Trace1170_Auto_2593::MIPI_DSI1_DATA2_N W MODELTYPE=RLGC N=4
+ Lo=
+ 3.29329672e-07
+ 5.61352492e-08 3.28124784e-07
+ 1.40721808e-08 4.13700270e-08 3.29271811e-07
+ 5.93108709e-09 1.20129166e-08 4.32861429e-08 3.30549982e-07
+ Co=
+ 1.04293727e-10
+ -7.17685138e-12 1.04600734e-10
+ -5.87245310e-13 -4.41858707e-12 1.04162413e-10
+ -2.47597650e-13 -5.23761021e-13 -4.72988808e-12 1.03849565e-10
+ Ro=
+ 3.96831067e+00
+ 0.00000000e+00 3.96831067e+00
+ 0.00000000e+00 0.00000000e+00 3.96831067e+00
+ 0.00000000e+00 0.00000000e+00 0.00000000e+00 3.96831067e+00
+ Go=
+ 0.00000000e+00
+ -0.00000000e+00 0.00000000e+00
+ -0.00000000e+00 -0.00000000e+00 0.00000000e+00
+ -0.00000000e+00 -0.00000000e+00 -0.00000000e+00 0.00000000e+00
+ Rs=
+ 1.55902417e-03
+ -0.00000000e+00 1.55902417e-03
+ -0.00000000e+00 -0.00000000e+00 1.55902417e-03
+ -0.00000000e+00 -0.00000000e+00 -0.00000000e+00 1.55902417e-03
+ Gd=
+ 2.03824169e-11
+ -4.86200272e-13 2.03603784e-11
+ -0.00000000e+00 -1.85342481e-13 2.03582580e-11
+ -0.00000000e+00 -0.00000000e+00 -2.05272863e-13 2.03810600e-11

.Model Wmodel_Trace1179::MIPI_DSI1_DATA2_N W MODELTYPE=RLGC N=1
+ Lo=
+ 3.32029740e-07
+ Co=
+ 1.03489020e-10
+ Ro=
+ 3.96831067e+00
+ Go=
+ 0.00000000e+00
+ Rs=
+ 1.55902417e-03
+ Gd=
+ 2.04067990e-11

.Model Wmodel_Trace1181::MIPI_DSI1_DATA2_N W MODELTYPE=RLGC N=1
+ Lo=
+ 3.32029740e-07
+ Co=
+ 1.03489020e-10
+ Ro=
+ 3.96831067e+00
+ Go=
+ 0.00000000e+00
+ Rs=
+ 1.55902417e-03
+ Gd=
+ 2.04067990e-11

.Model Wmodel_Trace1181_Auto_2617::MIPI_DSI1_DATA2_N W MODELTYPE=RLGC N=1
+ Lo=
+ 3.32029740e-07
+ Co=
+ 1.03489020e-10
+ Ro=
+ 3.96831067e+00
+ Go=
+ 0.00000000e+00
+ Rs=
+ 1.55902417e-03
+ Gd=
+ 2.04067990e-11

.Model Wmodel_Trace1183::MIPI_DSI1_DATA2_N W MODELTYPE=RLGC N=1
+ Lo=
+ 3.32029740e-07
+ Co=
+ 1.03489020e-10
+ Ro=
+ 3.96831067e+00
+ Go=
+ 0.00000000e+00
+ Rs=
+ 1.55902417e-03
+ Gd=
+ 2.04067990e-11

.Model Wmodel_Trace1185::MIPI_DSI1_DATA2_N W MODELTYPE=RLGC N=2
+ Lo=
+ 3.30749197e-07
+ 4.21553216e-08 3.30749197e-07
+ Co=
+ 1.03807621e-10
+ -4.51986433e-12 1.03807621e-10
+ Ro=
+ 3.96831067e+00
+ 0.00000000e+00 3.96831067e+00
+ Go=
+ 0.00000000e+00
+ -0.00000000e+00 0.00000000e+00
+ Rs=
+ 1.55902417e-03
+ -0.00000000e+00 1.55902417e-03
+ Gd=
+ 2.03827285e-11
+ -1.75027786e-13 2.03827285e-11

.Model Wmodel_Trace1185_Auto_2513::MIPI_DSI1_DATA2_N W MODELTYPE=RLGC N=1
+ Lo=
+ 3.32029740e-07
+ Co=
+ 1.03489020e-10
+ Ro=
+ 3.96831067e+00
+ Go=
+ 0.00000000e+00
+ Rs=
+ 1.55902417e-03
+ Gd=
+ 2.04067990e-11

.Model Wmodel_Trace1185_Auto_2519::MIPI_DSI1_DATA2_N W MODELTYPE=RLGC N=2
+ Lo=
+ 3.30740228e-07
+ 4.22796745e-08 3.30740228e-07
+ Co=
+ 1.03810526e-10
+ -4.54093947e-12 1.03810526e-10
+ Ro=
+ 3.96831067e+00
+ 0.00000000e+00 3.96831067e+00
+ Go=
+ 0.00000000e+00
+ -0.00000000e+00 0.00000000e+00
+ Rs=
+ 1.55902417e-03
+ -0.00000000e+00 1.55902417e-03
+ Gd=
+ 2.03826546e-11
+ -1.77144501e-13 2.03826546e-11

.Model Wmodel_Trace1185_Auto_2520::MIPI_DSI1_DATA2_N W MODELTYPE=RLGC N=1
+ Lo=
+ 3.32029740e-07
+ Co=
+ 1.03489020e-10
+ Ro=
+ 3.96831067e+00
+ Go=
+ 0.00000000e+00
+ Rs=
+ 1.55902417e-03
+ Gd=
+ 2.04067990e-11

.Model Wmodel_Trace1185_Auto_2524::MIPI_DSI1_DATA2_N W MODELTYPE=RLGC N=1
+ Lo=
+ 3.32029740e-07
+ Co=
+ 1.03489020e-10
+ Ro=
+ 3.96831067e+00
+ Go=
+ 0.00000000e+00
+ Rs=
+ 1.55902417e-03
+ Gd=
+ 2.04067990e-11

.Model Wmodel_Trace1186_Auto_2180::MIPI_DSI1_DATA2_N W MODELTYPE=RLGC N=1
+ Lo=
+ 3.32029740e-07
+ Co=
+ 1.03489020e-10
+ Ro=
+ 3.96831067e+00
+ Go=
+ 0.00000000e+00
+ Rs=
+ 1.55902417e-03
+ Gd=
+ 2.04067990e-11

.Model Wmodel_Trace1186_Auto_2194::MIPI_DSI1_DATA2_N W MODELTYPE=RLGC N=1
+ Lo=
+ 3.32029740e-07
+ Co=
+ 1.03489020e-10
+ Ro=
+ 3.96831067e+00
+ Go=
+ 0.00000000e+00
+ Rs=
+ 1.55902417e-03
+ Gd=
+ 2.04067990e-11

.Model Wmodel_Trace1187::MIPI_DSI1_DATA2_P W MODELTYPE=RLGC N=1
+ Lo=
+ 3.58484574e-07
+ Co=
+ 9.37055974e-11
+ Ro=
+ 4.84133902e+00
+ Go=
+ 0.00000000e+00
+ Rs=
+ 1.72420198e-03
+ Gd=
+ 1.82370500e-11

.Model Wmodel_Trace1188_Auto_905::MIPI_DSI1_DATA2_P W MODELTYPE=RLGC N=1
+ Lo=
+ 3.32029740e-07
+ Co=
+ 1.03489020e-10
+ Ro=
+ 3.96831067e+00
+ Go=
+ 0.00000000e+00
+ Rs=
+ 1.55902417e-03
+ Gd=
+ 2.04067990e-11

.Model Wmodel_Trace1188_Auto_921::MIPI_DSI1_DATA2_P W MODELTYPE=RLGC N=1
+ Lo=
+ 3.32029740e-07
+ Co=
+ 1.03489020e-10
+ Ro=
+ 3.96831067e+00
+ Go=
+ 0.00000000e+00
+ Rs=
+ 1.55902417e-03
+ Gd=
+ 2.04067990e-11

.Model Wmodel_Trace1188_Auto_931::MIPI_DSI1_DATA2_P W MODELTYPE=RLGC N=1
+ Lo=
+ 3.32029740e-07
+ Co=
+ 1.03489020e-10
+ Ro=
+ 3.96831067e+00
+ Go=
+ 0.00000000e+00
+ Rs=
+ 1.55902417e-03
+ Gd=
+ 2.04067990e-11

.Model Wmodel_Trace1188_Auto_939::MIPI_DSI1_DATA2_P W MODELTYPE=RLGC N=4
+ Lo=
+ 3.31211238e-07
+ 3.27989130e-08 3.28635320e-07
+ 1.20333713e-08 5.59116568e-08 3.28126663e-07
+ 5.26129181e-09 1.41169082e-08 4.16641660e-08 3.30628490e-07
+ Co=
+ 1.03650423e-10
+ -3.06285839e-12 1.04440260e-10
+ -5.22577966e-13 -7.14631263e-12 1.04599641e-10
+ -2.39492992e-13 -5.93355199e-13 -4.45843857e-12 1.03815945e-10
+ Ro=
+ 3.96831067e+00
+ 0.00000000e+00 3.96831067e+00
+ 0.00000000e+00 0.00000000e+00 3.96831067e+00
+ 0.00000000e+00 0.00000000e+00 0.00000000e+00 3.96831067e+00
+ Go=
+ 0.00000000e+00
+ -0.00000000e+00 0.00000000e+00
+ -0.00000000e+00 -0.00000000e+00 0.00000000e+00
+ -0.00000000e+00 -0.00000000e+00 -0.00000000e+00 0.00000000e+00
+ Rs=
+ 1.55902417e-03
+ -0.00000000e+00 1.55902417e-03
+ -0.00000000e+00 -0.00000000e+00 1.55902417e-03
+ -0.00000000e+00 -0.00000000e+00 -0.00000000e+00 1.55902417e-03
+ Gd=
+ 2.03889085e-11
+ -5.57262915e-14 2.03666654e-11
+ -0.00000000e+00 -4.88241760e-13 2.03603187e-11
+ -0.00000000e+00 -0.00000000e+00 -1.81845332e-13 2.03817488e-11

.Model Wmodel_Trace1188_Auto_953::MIPI_DSI1_DATA2_P W MODELTYPE=RLGC N=4
+ Lo=
+ 3.30948639e-07
+ 3.75051107e-08 3.29189482e-07
+ 1.20066439e-08 4.78045545e-08 3.28917413e-07
+ 5.26265407e-09 1.28626029e-08 4.17848020e-08 3.30648287e-07
+ Co=
+ 1.03725013e-10
+ -3.77230631e-12 1.04207261e-10
+ -5.29095557e-13 -5.55389644e-12 1.04295022e-10
+ -2.36373887e-13 -5.58412967e-13 -4.47384109e-12 1.03815164e-10
+ Ro=
+ 3.96831067e+00
+ 0.00000000e+00 3.96831067e+00
+ 0.00000000e+00 0.00000000e+00 3.96831067e+00
+ 0.00000000e+00 0.00000000e+00 0.00000000e+00 3.96831067e+00
+ Go=
+ 0.00000000e+00
+ -0.00000000e+00 0.00000000e+00
+ -0.00000000e+00 -0.00000000e+00 0.00000000e+00
+ -0.00000000e+00 -0.00000000e+00 -0.00000000e+00 0.00000000e+00
+ Rs=
+ 1.55902417e-03
+ -0.00000000e+00 1.55902417e-03
+ -0.00000000e+00 -0.00000000e+00 1.55902417e-03
+ -0.00000000e+00 -0.00000000e+00 -0.00000000e+00 1.55902417e-03
+ Gd=
+ 2.03849136e-11
+ -1.13556681e-13 2.03597953e-11
+ -0.00000000e+00 -3.01008030e-13 2.03570191e-11
+ -0.00000000e+00 -0.00000000e+00 -1.80900554e-13 2.03818135e-11

.Model Wmodel_Trace1189::MIPI_DSI1_DATA2_P W MODELTYPE=RLGC N=1
+ Lo=
+ 3.32029740e-07
+ Co=
+ 1.03489020e-10
+ Ro=
+ 3.96831067e+00
+ Go=
+ 0.00000000e+00
+ Rs=
+ 1.55902417e-03
+ Gd=
+ 2.04067990e-11

.Model Wmodel_Trace1190::MIPI_DSI1_DATA2_P W MODELTYPE=RLGC N=4
+ Lo=
+ 3.30648800e-07
+ 4.17584105e-08 3.28907072e-07
+ 1.28411599e-08 4.77481469e-08 3.28905519e-07
+ 5.50073898e-09 1.28455912e-08 4.17810679e-08 3.30647093e-07
+ Co=
+ 1.03814691e-10
+ -4.46980441e-12 1.04295039e-10
+ -5.55577348e-13 -5.54682893e-12 1.04295560e-10
+ -2.42989683e-13 -5.55724729e-13 -4.47365408e-12 1.03815225e-10
+ Ro=
+ 3.96831067e+00
+ 0.00000000e+00 3.96831067e+00
+ 0.00000000e+00 0.00000000e+00 3.96831067e+00
+ 0.00000000e+00 0.00000000e+00 0.00000000e+00 3.96831067e+00
+ Go=
+ 0.00000000e+00
+ -0.00000000e+00 0.00000000e+00
+ -0.00000000e+00 -0.00000000e+00 0.00000000e+00
+ -0.00000000e+00 -0.00000000e+00 -0.00000000e+00 0.00000000e+00
+ Rs=
+ 1.55902417e-03
+ -0.00000000e+00 1.55902417e-03
+ -0.00000000e+00 -0.00000000e+00 1.55902417e-03
+ -0.00000000e+00 -0.00000000e+00 -0.00000000e+00 1.55902417e-03
+ Gd=
+ 2.03818220e-11
+ -1.80529704e-13 2.03569813e-11
+ -0.00000000e+00 -3.01564054e-13 2.03569691e-11
+ -0.00000000e+00 -0.00000000e+00 -1.80917851e-13 2.03818081e-11

.Model Wmodel_Trace1191::MIPI_DSI1_DATA2_P W MODELTYPE=RLGC N=1
+ Lo=
+ 3.32029740e-07
+ Co=
+ 1.03489020e-10
+ Ro=
+ 3.96831067e+00
+ Go=
+ 0.00000000e+00
+ Rs=
+ 1.55902417e-03
+ Gd=
+ 2.04067990e-11

.Model Wmodel_Trace1192::MIPI_DSI1_DATA2_P W MODELTYPE=RLGC N=4
+ Lo=
+ 3.30948639e-07
+ 3.75051107e-08 3.29189482e-07
+ 1.20066439e-08 4.78045545e-08 3.28917413e-07
+ 5.26265407e-09 1.28626029e-08 4.17848020e-08 3.30648287e-07
+ Co=
+ 1.03725013e-10
+ -3.77230631e-12 1.04207261e-10
+ -5.29095557e-13 -5.55389644e-12 1.04295022e-10
+ -2.36373887e-13 -5.58412967e-13 -4.47384109e-12 1.03815164e-10
+ Ro=
+ 3.96831067e+00
+ 0.00000000e+00 3.96831067e+00
+ 0.00000000e+00 0.00000000e+00 3.96831067e+00
+ 0.00000000e+00 0.00000000e+00 0.00000000e+00 3.96831067e+00
+ Go=
+ 0.00000000e+00
+ -0.00000000e+00 0.00000000e+00
+ -0.00000000e+00 -0.00000000e+00 0.00000000e+00
+ -0.00000000e+00 -0.00000000e+00 -0.00000000e+00 0.00000000e+00
+ Rs=
+ 1.55902417e-03
+ -0.00000000e+00 1.55902417e-03
+ -0.00000000e+00 -0.00000000e+00 1.55902417e-03
+ -0.00000000e+00 -0.00000000e+00 -0.00000000e+00 1.55902417e-03
+ Gd=
+ 2.03849136e-11
+ -1.13556681e-13 2.03597953e-11
+ -0.00000000e+00 -3.01008030e-13 2.03570191e-11
+ -0.00000000e+00 -0.00000000e+00 -1.80900554e-13 2.03818135e-11

.Model Wmodel_Trace1192_Auto_888::MIPI_DSI1_DATA2_P W MODELTYPE=RLGC N=1
+ Lo=
+ 3.32029740e-07
+ Co=
+ 1.03489020e-10
+ Ro=
+ 3.96831067e+00
+ Go=
+ 0.00000000e+00
+ Rs=
+ 1.55902417e-03
+ Gd=
+ 2.04067990e-11

.Model Wmodel_Trace1193::MIPI_DSI1_DATA2_P W MODELTYPE=RLGC N=4
+ Lo=
+ 3.30659715e-07
+ 4.18249378e-08 3.29272964e-07
+ 1.21350699e-08 4.34040955e-08 3.29272964e-07
+ 5.30322955e-09 1.21350699e-08 4.18249378e-08 3.30659715e-07
+ Co=
+ 1.03814284e-10
+ -4.47850988e-12 1.04170740e-10
+ -5.35092318e-13 -4.76008133e-12 1.04170740e-10
+ -2.35057088e-13 -5.35092318e-13 -4.47850988e-12 1.03814284e-10
+ Ro=
+ 3.96831067e+00
+ 0.00000000e+00 3.96831067e+00
+ 0.00000000e+00 0.00000000e+00 3.96831067e+00
+ 0.00000000e+00 0.00000000e+00 0.00000000e+00 3.96831067e+00
+ Go=
+ 0.00000000e+00
+ -0.00000000e+00 0.00000000e+00
+ -0.00000000e+00 -0.00000000e+00 0.00000000e+00
+ -0.00000000e+00 -0.00000000e+00 -0.00000000e+00 0.00000000e+00
+ Rs=
+ 1.55902417e-03
+ -0.00000000e+00 1.55902417e-03
+ -0.00000000e+00 -0.00000000e+00 1.55902417e-03
+ -0.00000000e+00 -0.00000000e+00 -0.00000000e+00 1.55902417e-03
+ Gd=
+ 2.03818679e-11
+ -1.80048190e-13 2.03581722e-11
+ -0.00000000e+00 -2.15849940e-13 2.03581722e-11
+ -0.00000000e+00 -0.00000000e+00 -1.80048190e-13 2.03818679e-11

.Model Wmodel_Trace1194::MIPI_DSI1_DATA2_P W MODELTYPE=RLGC N=2
+ Lo=
+ 3.30748904e-07
+ 4.21593990e-08 3.30748904e-07
+ Co=
+ 1.03807716e-10
+ -4.52055469e-12 1.03807716e-10
+ Ro=
+ 3.96831067e+00
+ 0.00000000e+00 3.96831067e+00
+ Go=
+ 0.00000000e+00
+ -0.00000000e+00 0.00000000e+00
+ Rs=
+ 1.55902417e-03
+ -0.00000000e+00 1.55902417e-03
+ Gd=
+ 2.03827260e-11
+ -1.75097034e-13 2.03827260e-11

.Model Wmodel_Trace1194_Auto_2124::MIPI_DSI1_DATA2_P W MODELTYPE=RLGC N=1
+ Lo=
+ 3.32029740e-07
+ Co=
+ 1.03489020e-10
+ Ro=
+ 3.96831067e+00
+ Go=
+ 0.00000000e+00
+ Rs=
+ 1.55902417e-03
+ Gd=
+ 2.04067990e-11

.Model Wmodel_Trace1198::MIPI_DSI1_DATA2_P W MODELTYPE=RLGC N=1
+ Lo=
+ 3.32029740e-07
+ Co=
+ 1.03489020e-10
+ Ro=
+ 3.96831067e+00
+ Go=
+ 0.00000000e+00
+ Rs=
+ 1.55902417e-03
+ Gd=
+ 2.04067990e-11

.Model Wmodel_Trace1208#BP0::MIPI_DSI1_DATA2_P W MODELTYPE=RLGC N=1
+ Lo=
+ 8.24350330e-07
+ Co=
+ 3.67394016e-11
+ Ro=
+ 3.96831067e+00
+ Go=
+ 0.00000000e+00
+ Rs=
+ 1.02517469e-03
+ Gd=
+ 6.50321060e-12

.Model Wmodel_Trace1208#BP1::MIPI_DSI1_DATA2_P W MODELTYPE=RLGC N=1
+ Lo=
+ 3.32029740e-07
+ Co=
+ 1.03489020e-10
+ Ro=
+ 3.96831067e+00
+ Go=
+ 0.00000000e+00
+ Rs=
+ 1.55902417e-03
+ Gd=
+ 2.04067990e-11

.Model Wmodel_Trace1208#BP1_Auto_2872::MIPI_DSI1_DATA2_P W MODELTYPE=RLGC N=2
+ Lo=
+ 3.30748904e-07
+ 4.21593990e-08 3.30748904e-07
+ Co=
+ 1.03807716e-10
+ -4.52055469e-12 1.03807716e-10
+ Ro=
+ 3.96831067e+00
+ 0.00000000e+00 3.96831067e+00
+ Go=
+ 0.00000000e+00
+ -0.00000000e+00 0.00000000e+00
+ Rs=
+ 1.55902417e-03
+ -0.00000000e+00 1.55902417e-03
+ Gd=
+ 2.03827260e-11
+ -1.75097034e-13 2.03827260e-11

.Model Wmodel_Trace1208::MIPI_DSI1_DATA2_P W MODELTYPE=RLGC N=1
+ Lo=
+ 3.32029740e-07
+ Co=
+ 1.03489020e-10
+ Ro=
+ 3.96831067e+00
+ Go=
+ 0.00000000e+00
+ Rs=
+ 1.55902417e-03
+ Gd=
+ 2.04067990e-11

.Model Wmodel_Trace1209::MIPI_DSI1_DATA2_P W MODELTYPE=RLGC N=2
+ Lo=
+ 3.31032063e-07
+ 3.79301273e-08 3.31032063e-07
+ Co=
+ 1.03719639e-10
+ -3.82925212e-12 1.03719639e-10
+ Ro=
+ 3.96831067e+00
+ 0.00000000e+00 3.96831067e+00
+ Go=
+ 0.00000000e+00
+ -0.00000000e+00 0.00000000e+00
+ Rs=
+ 1.55902417e-03
+ -0.00000000e+00 1.55902417e-03
+ Gd=
+ 2.03857107e-11
+ -1.09077726e-13 2.03857107e-11

.Model Wmodel_Trace1210::MIPI_DSI1_DATA2_P W MODELTYPE=RLGC N=1
+ Lo=
+ 3.32029740e-07
+ Co=
+ 1.03489020e-10
+ Ro=
+ 3.96831067e+00
+ Go=
+ 0.00000000e+00
+ Rs=
+ 1.55902417e-03
+ Gd=
+ 2.04067990e-11

.Model Wmodel_Trace1210_Auto_2870::MIPI_DSI1_DATA2_P W MODELTYPE=RLGC N=2
+ Lo=
+ 3.31255706e-07
+ 3.40486162e-08 3.31255706e-07
+ Co=
+ 1.03655649e-10
+ -3.23974310e-12 1.03655649e-10
+ Ro=
+ 3.96831067e+00
+ 0.00000000e+00 3.96831067e+00
+ Go=
+ 0.00000000e+00
+ -0.00000000e+00 0.00000000e+00
+ Rs=
+ 1.55902417e-03
+ -0.00000000e+00 1.55902417e-03
+ Gd=
+ 2.03890053e-11
+ -5.89962403e-14 2.03890053e-11

.Model Wmodel_Trace1211::MIPI_DSI1_DATA2_P W MODELTYPE=RLGC N=1
+ Lo=
+ 3.32029740e-07
+ Co=
+ 1.03489020e-10
+ Ro=
+ 3.96831067e+00
+ Go=
+ 0.00000000e+00
+ Rs=
+ 1.55902417e-03
+ Gd=
+ 2.04067990e-11

.Model Wmodel_Trace1213::MIPI_DSI1_DATA2_P W MODELTYPE=RLGC N=1
+ Lo=
+ 3.32029740e-07
+ Co=
+ 1.03489020e-10
+ Ro=
+ 3.96831067e+00
+ Go=
+ 0.00000000e+00
+ Rs=
+ 1.55902417e-03
+ Gd=
+ 2.04067990e-11

.Model Wmodel_Trace1218::MIPI_DSI1_DATA2_P W MODELTYPE=RLGC N=1
+ Lo=
+ 3.32029740e-07
+ Co=
+ 1.03489020e-10
+ Ro=
+ 3.96831067e+00
+ Go=
+ 0.00000000e+00
+ Rs=
+ 1.55902417e-03
+ Gd=
+ 2.04067990e-11

.Model Wmodel_Trace1223::MIPI_DSI1_DATA2_P W MODELTYPE=RLGC N=1
+ Lo=
+ 3.32029740e-07
+ Co=
+ 1.03489020e-10
+ Ro=
+ 3.96831067e+00
+ Go=
+ 0.00000000e+00
+ Rs=
+ 1.55902417e-03
+ Gd=
+ 2.04067990e-11

.Model Wmodel_Trace1225::MIPI_DSI1_DATA2_P W MODELTYPE=RLGC N=1
+ Lo=
+ 3.32029740e-07
+ Co=
+ 1.03489020e-10
+ Ro=
+ 3.96831067e+00
+ Go=
+ 0.00000000e+00
+ Rs=
+ 1.55902417e-03
+ Gd=
+ 2.04067990e-11

.Model Wmodel_Trace1227::MIPI_DSI1_DATA2_P W MODELTYPE=RLGC N=1
+ Lo=
+ 3.32029740e-07
+ Co=
+ 1.03489020e-10
+ Ro=
+ 3.96831067e+00
+ Go=
+ 0.00000000e+00
+ Rs=
+ 1.55902417e-03
+ Gd=
+ 2.04067990e-11

.Model Wmodel_Trace1236::MIPI_DSI1_DATA2_P W MODELTYPE=RLGC N=1
+ Lo=
+ 3.32029740e-07
+ Co=
+ 1.03489020e-10
+ Ro=
+ 3.96831067e+00
+ Go=
+ 0.00000000e+00
+ Rs=
+ 1.55902417e-03
+ Gd=
+ 2.04067990e-11

.Model Wmodel_Trace1236_Auto_2890::MIPI_DSI1_DATA2_P W MODELTYPE=RLGC N=4
+ Lo=
+ 3.30664868e-07
+ 4.24702196e-08 3.30198588e-07
+ 9.22531587e-09 2.73685101e-08 3.30192007e-07
+ 4.43832837e-09 9.23599971e-09 4.25617026e-08 3.30658055e-07
+ Co=
+ 1.03822926e-10
+ -4.58082074e-12 1.03911677e-10
+ -4.33089682e-13 -2.32345756e-12 1.03913853e-10
+ -1.99094792e-13 -4.33478475e-13 -4.59645283e-12 1.03825123e-10
+ Ro=
+ 3.96831067e+00
+ 0.00000000e+00 3.96831067e+00
+ 0.00000000e+00 0.00000000e+00 3.96831067e+00
+ 0.00000000e+00 0.00000000e+00 0.00000000e+00 3.96831067e+00
+ Go=
+ 0.00000000e+00
+ -0.00000000e+00 0.00000000e+00
+ -0.00000000e+00 -0.00000000e+00 0.00000000e+00
+ -0.00000000e+00 -0.00000000e+00 -0.00000000e+00 0.00000000e+00
+ Rs=
+ 1.55902417e-03
+ -0.00000000e+00 1.55902417e-03
+ -0.00000000e+00 -0.00000000e+00 1.55902417e-03
+ -0.00000000e+00 -0.00000000e+00 -0.00000000e+00 1.55902417e-03
+ Gd=
+ 2.03818420e-11
+ -1.85712696e-13 2.03703885e-11
+ -0.00000000e+00 -7.54572908e-15 2.03703391e-11
+ -0.00000000e+00 -0.00000000e+00 -1.87300246e-13 2.03817894e-11

.Model Wmodel_Trace1246::MIPI_DSI1_DATA2_P W MODELTYPE=RLGC N=1
+ Lo=
+ 3.32029740e-07
+ Co=
+ 1.03489020e-10
+ Ro=
+ 3.96831067e+00
+ Go=
+ 0.00000000e+00
+ Rs=
+ 1.55902417e-03
+ Gd=
+ 2.04067990e-11

.Model Wmodel_Trace1248::MIPI_DSI1_DATA2_P W MODELTYPE=RLGC N=1
+ Lo=
+ 3.32029740e-07
+ Co=
+ 1.03489020e-10
+ Ro=
+ 3.96831067e+00
+ Go=
+ 0.00000000e+00
+ Rs=
+ 1.55902417e-03
+ Gd=
+ 2.04067990e-11

.Model Wmodel_Trace1252::MIPI_DSI1_DATA2_P W MODELTYPE=RLGC N=1
+ Lo=
+ 3.32029740e-07
+ Co=
+ 1.03489020e-10
+ Ro=
+ 3.96831067e+00
+ Go=
+ 0.00000000e+00
+ Rs=
+ 1.55902417e-03
+ Gd=
+ 2.04067990e-11

.Model Wmodel_Trace1253::MIPI_DSI1_DATA2_P W MODELTYPE=RLGC N=1
+ Lo=
+ 3.32029740e-07
+ Co=
+ 1.03489020e-10
+ Ro=
+ 3.96831067e+00
+ Go=
+ 0.00000000e+00
+ Rs=
+ 1.55902417e-03
+ Gd=
+ 2.04067990e-11

.Model Wmodel_Trace1253_Auto_2125::MIPI_DSI1_DATA2_P W MODELTYPE=RLGC N=2
+ Lo=
+ 3.30748548e-07
+ 4.21643405e-08 3.30748548e-07
+ Co=
+ 1.03807831e-10
+ -4.52139143e-12 1.03807831e-10
+ Ro=
+ 3.96831067e+00
+ 0.00000000e+00 3.96831067e+00
+ Go=
+ 0.00000000e+00
+ -0.00000000e+00 0.00000000e+00
+ Rs=
+ 1.55902417e-03
+ -0.00000000e+00 1.55902417e-03
+ Gd=
+ 2.03827231e-11
+ -1.75180973e-13 2.03827231e-11

.Model Wmodel_Trace1255::MIPI_DSI1_DATA2_P W MODELTYPE=RLGC N=1
+ Lo=
+ 3.32029740e-07
+ Co=
+ 1.03489020e-10
+ Ro=
+ 3.96831067e+00
+ Go=
+ 0.00000000e+00
+ Rs=
+ 1.55902417e-03
+ Gd=
+ 2.04067990e-11

.Model Wmodel_Trace1258::MIPI_DSI1_DATA2_P W MODELTYPE=RLGC N=1
+ Lo=
+ 3.32029740e-07
+ Co=
+ 1.03489020e-10
+ Ro=
+ 3.96831067e+00
+ Go=
+ 0.00000000e+00
+ Rs=
+ 1.55902417e-03
+ Gd=
+ 2.04067990e-11

.Model Wmodel_Trace1258_Auto_2128::MIPI_DSI1_DATA2_P W MODELTYPE=RLGC N=2
+ Lo=
+ 3.30706509e-07
+ 4.27426274e-08 3.30706509e-07
+ Co=
+ 1.03821510e-10
+ -4.61977037e-12 1.03821510e-10
+ Ro=
+ 3.96831067e+00
+ 0.00000000e+00 3.96831067e+00
+ Go=
+ 0.00000000e+00
+ -0.00000000e+00 0.00000000e+00
+ Rs=
+ 1.55902417e-03
+ -0.00000000e+00 1.55902417e-03
+ Gd=
+ 2.03823877e-11
+ -1.85111578e-13 2.03823877e-11

.Model Wmodel_Trace1260::MIPI_DSI1_DATA2_P W MODELTYPE=RLGC N=1
+ Lo=
+ 3.32029740e-07
+ Co=
+ 1.03489020e-10
+ Ro=
+ 3.96831067e+00
+ Go=
+ 0.00000000e+00
+ Rs=
+ 1.55902417e-03
+ Gd=
+ 2.04067990e-11

.Model Wmodel_Trace1262#BP0::MIPI_DSI1_DATA2_P W MODELTYPE=RLGC N=1
+ Lo=
+ 8.24350330e-07
+ Co=
+ 3.67394016e-11
+ Ro=
+ 3.96831067e+00
+ Go=
+ 0.00000000e+00
+ Rs=
+ 1.02517469e-03
+ Gd=
+ 6.50321060e-12

.Model Wmodel_Trace1262#BP1::MIPI_DSI1_DATA2_P W MODELTYPE=RLGC N=1
+ Lo=
+ 3.32029740e-07
+ Co=
+ 1.03489020e-10
+ Ro=
+ 3.96831067e+00
+ Go=
+ 0.00000000e+00
+ Rs=
+ 1.55902417e-03
+ Gd=
+ 2.04067990e-11

.Model Wmodel_Trace1262::MIPI_DSI1_DATA2_P W MODELTYPE=RLGC N=2
+ Lo=
+ 3.30784836e-07
+ 4.16559655e-08 3.30784836e-07
+ Co=
+ 1.03796142e-10
+ -4.43566005e-12 1.03796142e-10
+ Ro=
+ 3.96831067e+00
+ 0.00000000e+00 3.96831067e+00
+ Go=
+ 0.00000000e+00
+ -0.00000000e+00 0.00000000e+00
+ Rs=
+ 1.55902417e-03
+ -0.00000000e+00 1.55902417e-03
+ Gd=
+ 2.03830344e-11
+ -1.66627638e-13 2.03830344e-11

.Model Wmodel_Trace1262_Auto_2127::MIPI_DSI1_DATA2_P W MODELTYPE=RLGC N=1
+ Lo=
+ 3.32029740e-07
+ Co=
+ 1.03489020e-10
+ Ro=
+ 3.96831067e+00
+ Go=
+ 0.00000000e+00
+ Rs=
+ 1.55902417e-03
+ Gd=
+ 2.04067990e-11

.Model Wmodel_Trace1266::MIPI_DSI1_DATA2_P W MODELTYPE=RLGC N=2
+ Lo=
+ 3.30739043e-07
+ 4.22960763e-08 3.30739043e-07
+ Co=
+ 1.03810911e-10
+ -4.54372237e-12 1.03810911e-10
+ Ro=
+ 3.96831067e+00
+ 0.00000000e+00 3.96831067e+00
+ Go=
+ 0.00000000e+00
+ -0.00000000e+00 0.00000000e+00
+ Rs=
+ 1.55902417e-03
+ -0.00000000e+00 1.55902417e-03
+ Gd=
+ 2.03826449e-11
+ -1.77424428e-13 2.03826449e-11

.Model Wmodel_Trace1266_Auto_2132::MIPI_DSI1_DATA2_P W MODELTYPE=RLGC N=1
+ Lo=
+ 3.32029740e-07
+ Co=
+ 1.03489020e-10
+ Ro=
+ 3.96831067e+00
+ Go=
+ 0.00000000e+00
+ Rs=
+ 1.55902417e-03
+ Gd=
+ 2.04067990e-11

.Model Wmodel_Trace1267::MIPI_DSI1_DATA2_P W MODELTYPE=RLGC N=1
+ Lo=
+ 3.32029740e-07
+ Co=
+ 1.03489020e-10
+ Ro=
+ 3.96831067e+00
+ Go=
+ 0.00000000e+00
+ Rs=
+ 1.55902417e-03
+ Gd=
+ 2.04067990e-11

.Model Wmodel_Trace1267_Auto_2133::MIPI_DSI1_DATA2_P W MODELTYPE=RLGC N=2
+ Lo=
+ 3.30791524e-07
+ 4.15613158e-08 3.30791524e-07
+ Co=
+ 1.03794000e-10
+ -4.41977676e-12 1.03794000e-10
+ Ro=
+ 3.96831067e+00
+ 0.00000000e+00 3.96831067e+00
+ Go=
+ 0.00000000e+00
+ -0.00000000e+00 0.00000000e+00
+ Rs=
+ 1.55902417e-03
+ -0.00000000e+00 1.55902417e-03
+ Gd=
+ 2.03830940e-11
+ -1.65053512e-13 2.03830940e-11

.Model Wmodel_Trace1271::MIPI_DSI1_DATA2_P W MODELTYPE=RLGC N=1
+ Lo=
+ 3.32029740e-07
+ Co=
+ 1.03489020e-10
+ Ro=
+ 3.96831067e+00
+ Go=
+ 0.00000000e+00
+ Rs=
+ 1.55902417e-03
+ Gd=
+ 2.04067990e-11

.Model Wmodel_Trace1282::MIPI_DSI1_DATA2_P W MODELTYPE=RLGC N=1
+ Lo=
+ 3.32029740e-07
+ Co=
+ 1.03489020e-10
+ Ro=
+ 3.96831067e+00
+ Go=
+ 0.00000000e+00
+ Rs=
+ 1.55902417e-03
+ Gd=
+ 2.04067990e-11

.Model Wmodel_Trace1284::MIPI_DSI1_DATA2_P W MODELTYPE=RLGC N=2
+ Lo=
+ 3.31623759e-07
+ 2.58042749e-08 3.31623759e-07
+ Co=
+ 1.03563549e-10
+ -2.13865996e-12 1.03563549e-10
+ Ro=
+ 3.96831067e+00
+ 0.00000000e+00 3.96831067e+00
+ Go=
+ 0.00000000e+00
+ -0.00000000e+00 0.00000000e+00
+ Rs=
+ 1.55902417e-03
+ -0.00000000e+00 1.55902417e-03
+ Gd=
+ 2.03963380e-11
+ -0.00000000e+00 2.03963380e-11

.Model Wmodel_Trace1286::MIPI_DSI1_DATA2_P W MODELTYPE=RLGC N=1
+ Lo=
+ 3.32029740e-07
+ Co=
+ 1.03489020e-10
+ Ro=
+ 3.96831067e+00
+ Go=
+ 0.00000000e+00
+ Rs=
+ 1.55902417e-03
+ Gd=
+ 2.04067990e-11

.Model Wmodel_Trace1290::MIPI_DSI1_DATA2_P W MODELTYPE=RLGC N=1
+ Lo=
+ 8.24350330e-07
+ Co=
+ 3.67394016e-11
+ Ro=
+ 3.96831067e+00
+ Go=
+ 0.00000000e+00
+ Rs=
+ 1.02517469e-03
+ Gd=
+ 6.50321060e-12

.Model Wmodel_Trace1294::MIPI_DSI1_DATA2_P W MODELTYPE=RLGC N=1
+ Lo=
+ 3.32029740e-07
+ Co=
+ 1.03489020e-10
+ Ro=
+ 3.96831067e+00
+ Go=
+ 0.00000000e+00
+ Rs=
+ 1.55902417e-03
+ Gd=
+ 2.04067990e-11

.Model Wmodel_Trace1295::MIPI_DSI1_DATA2_P W MODELTYPE=RLGC N=1
+ Lo=
+ 8.24350330e-07
+ Co=
+ 3.67394016e-11
+ Ro=
+ 3.96831067e+00
+ Go=
+ 0.00000000e+00
+ Rs=
+ 1.02517469e-03
+ Gd=
+ 6.50321060e-12

.Model Wmodel_Trace1299::MIPI_DSI1_DATA2_P W MODELTYPE=RLGC N=1
+ Lo=
+ 3.32029740e-07
+ Co=
+ 1.03489020e-10
+ Ro=
+ 3.96831067e+00
+ Go=
+ 0.00000000e+00
+ Rs=
+ 1.55902417e-03
+ Gd=
+ 2.04067990e-11

.Model Wmodel_Trace1304#BP0::MIPI_DSI1_DATA2_P W MODELTYPE=RLGC N=1
+ Lo=
+ 3.32029740e-07
+ Co=
+ 1.03489020e-10
+ Ro=
+ 3.96831067e+00
+ Go=
+ 0.00000000e+00
+ Rs=
+ 1.55902417e-03
+ Gd=
+ 2.04067990e-11

.Model Wmodel_Trace1304::MIPI_DSI1_DATA2_P W MODELTYPE=RLGC N=1
+ Lo=
+ 8.24350330e-07
+ Co=
+ 3.67394016e-11
+ Ro=
+ 3.96831067e+00
+ Go=
+ 0.00000000e+00
+ Rs=
+ 1.02517469e-03
+ Gd=
+ 6.50321060e-12

.Model Wmodel_Trace1306::MIPI_DSI1_DATA2_P W MODELTYPE=RLGC N=1
+ Lo=
+ 3.32029740e-07
+ Co=
+ 1.03489020e-10
+ Ro=
+ 3.96831067e+00
+ Go=
+ 0.00000000e+00
+ Rs=
+ 1.55902417e-03
+ Gd=
+ 2.04067990e-11

.Model Wmodel_Trace1315::MIPI_DSI1_DATA2_P W MODELTYPE=RLGC N=1
+ Lo=
+ 3.32029740e-07
+ Co=
+ 1.03489020e-10
+ Ro=
+ 3.96831067e+00
+ Go=
+ 0.00000000e+00
+ Rs=
+ 1.55902417e-03
+ Gd=
+ 2.04067990e-11

.Model Wmodel_Trace1326::MIPI_DSI1_DATA2_P W MODELTYPE=RLGC N=1
+ Lo=
+ 3.32029740e-07
+ Co=
+ 1.03489020e-10
+ Ro=
+ 3.96831067e+00
+ Go=
+ 0.00000000e+00
+ Rs=
+ 1.55902417e-03
+ Gd=
+ 2.04067990e-11

.Model Wmodel_Trace1328::MIPI_DSI1_DATA2_P W MODELTYPE=RLGC N=3
+ Lo=
+ 3.31602095e-07
+ 2.57166043e-08 3.31207254e-07
+ 6.87193900e-09 2.60668532e-08 3.31589293e-07
+ Co=
+ 1.03565750e-10
+ -2.12639058e-12 1.03640109e-10
+ -3.51342814e-13 -2.16891570e-12 1.03568627e-10
+ Ro=
+ 3.96831067e+00
+ 0.00000000e+00 3.96831067e+00
+ 0.00000000e+00 0.00000000e+00 3.96831067e+00
+ Go=
+ 0.00000000e+00
+ -0.00000000e+00 0.00000000e+00
+ -0.00000000e+00 -0.00000000e+00 0.00000000e+00
+ Rs=
+ 1.55902417e-03
+ -0.00000000e+00 1.55902417e-03
+ -0.00000000e+00 -0.00000000e+00 1.55902417e-03
+ Gd=
+ 2.03959968e-11
+ -0.00000000e+00 2.03858142e-11
+ -0.00000000e+00 -0.00000000e+00 2.03957015e-11

.Model Wmodel_Trace1332::MIPI_DSI1_DATA2_P W MODELTYPE=RLGC N=1
+ Lo=
+ 3.32029740e-07
+ Co=
+ 1.03489020e-10
+ Ro=
+ 3.96831067e+00
+ Go=
+ 0.00000000e+00
+ Rs=
+ 1.55902417e-03
+ Gd=
+ 2.04067990e-11

.Model Wmodel_Trace1334::MIPI_DSI1_DATA2_P W MODELTYPE=RLGC N=1
+ Lo=
+ 3.32029740e-07
+ Co=
+ 1.03489020e-10
+ Ro=
+ 3.96831067e+00
+ Go=
+ 0.00000000e+00
+ Rs=
+ 1.55902417e-03
+ Gd=
+ 2.04067990e-11

.Model Wmodel_Trace1334_Auto_2542::MIPI_DSI1_DATA2_P W MODELTYPE=RLGC N=4
+ Lo=
+ 3.30731913e-07
+ 4.15491926e-08 3.30256184e-07
+ 9.16147205e-09 2.75776828e-08 3.30190928e-07
+ 4.41373422e-09 9.27073889e-09 4.24723084e-08 3.30664279e-07
+ Co=
+ 1.03801431e-10
+ -4.42474548e-12 1.03892242e-10
+ -4.31278002e-13 -2.35033897e-12 1.03913630e-10
+ -1.98646571e-13 -4.35278158e-13 -4.58121288e-12 1.03823036e-10
+ Ro=
+ 3.96831067e+00
+ 0.00000000e+00 3.96831067e+00
+ 0.00000000e+00 0.00000000e+00 3.96831067e+00
+ 0.00000000e+00 0.00000000e+00 0.00000000e+00 3.96831067e+00
+ Go=
+ 0.00000000e+00
+ -0.00000000e+00 0.00000000e+00
+ -0.00000000e+00 -0.00000000e+00 0.00000000e+00
+ -0.00000000e+00 -0.00000000e+00 -0.00000000e+00 0.00000000e+00
+ Rs=
+ 1.55902417e-03
+ -0.00000000e+00 1.55902417e-03
+ -0.00000000e+00 -0.00000000e+00 1.55902417e-03
+ -0.00000000e+00 -0.00000000e+00 -0.00000000e+00 1.55902417e-03
+ Gd=
+ 2.03823960e-11
+ -1.70078964e-13 2.03707446e-11
+ -0.00000000e+00 -8.94597953e-15 2.03702181e-11
+ -0.00000000e+00 -0.00000000e+00 -1.85801474e-13 2.03818367e-11

.Model Wmodel_Trace1334_Auto_2543::MIPI_DSI1_DATA2_P W MODELTYPE=RLGC N=1
+ Lo=
+ 3.32029740e-07
+ Co=
+ 1.03489020e-10
+ Ro=
+ 3.96831067e+00
+ Go=
+ 0.00000000e+00
+ Rs=
+ 1.55902417e-03
+ Gd=
+ 2.04067990e-11

.Model Wmodel_Trace1334_Auto_2552::MIPI_DSI1_DATA2_P W MODELTYPE=RLGC N=2
+ Lo=
+ 3.30714784e-07
+ 4.26296736e-08 3.30714784e-07
+ Co=
+ 1.03818806e-10
+ -4.60048301e-12 1.03818806e-10
+ Ro=
+ 3.96831067e+00
+ 0.00000000e+00 3.96831067e+00
+ Go=
+ 0.00000000e+00
+ -0.00000000e+00 0.00000000e+00
+ Rs=
+ 1.55902417e-03
+ -0.00000000e+00 1.55902417e-03
+ Gd=
+ 2.03824516e-11
+ -1.83155133e-13 2.03824516e-11

.Model Wmodel_Trace1334_Auto_2553::MIPI_DSI1_DATA2_P W MODELTYPE=RLGC N=1
+ Lo=
+ 3.32029740e-07
+ Co=
+ 1.03489020e-10
+ Ro=
+ 3.96831067e+00
+ Go=
+ 0.00000000e+00
+ Rs=
+ 1.55902417e-03
+ Gd=
+ 2.04067990e-11

.Model Wmodel_Trace1336::MIPI_DSI1_DATA2_P W MODELTYPE=RLGC N=1
+ Lo=
+ 3.32029740e-07
+ Co=
+ 1.03489020e-10
+ Ro=
+ 3.96831067e+00
+ Go=
+ 0.00000000e+00
+ Rs=
+ 1.55902417e-03
+ Gd=
+ 2.04067990e-11

.Model Wmodel_Trace1338::MIPI_DSI1_DATA2_P W MODELTYPE=RLGC N=1
+ Lo=
+ 3.32029740e-07
+ Co=
+ 1.03489020e-10
+ Ro=
+ 3.96831067e+00
+ Go=
+ 0.00000000e+00
+ Rs=
+ 1.55902417e-03
+ Gd=
+ 2.04067990e-11

.Model Wmodel_Trace1338_Auto_2478::MIPI_DSI1_DATA2_P W MODELTYPE=RLGC N=3
+ Lo=
+ 3.30715788e-07
+ 4.20879483e-08 3.30446490e-07
+ 8.17879736e-09 2.26146417e-08 3.31693121e-07
+ Co=
+ 1.03811071e-10
+ -4.51265011e-12 1.03859444e-10
+ -4.00078586e-13 -1.76263430e-12 1.03544737e-10
+ Ro=
+ 3.96831067e+00
+ 0.00000000e+00 3.96831067e+00
+ 0.00000000e+00 0.00000000e+00 3.96831067e+00
+ Go=
+ 0.00000000e+00
+ -0.00000000e+00 0.00000000e+00
+ -0.00000000e+00 -0.00000000e+00 0.00000000e+00
+ Rs=
+ 1.55902417e-03
+ -0.00000000e+00 1.55902417e-03
+ -0.00000000e+00 -0.00000000e+00 1.55902417e-03
+ Gd=
+ 2.03822875e-11
+ -1.77271080e-13 2.03750738e-11
+ -0.00000000e+00 -0.00000000e+00 2.03983385e-11

.Model Wmodel_Trace1338_Auto_2529::MIPI_DSI1_DATA2_P W MODELTYPE=RLGC N=1
+ Lo=
+ 3.32029740e-07
+ Co=
+ 1.03489020e-10
+ Ro=
+ 3.96831067e+00
+ Go=
+ 0.00000000e+00
+ Rs=
+ 1.55902417e-03
+ Gd=
+ 2.04067990e-11

.Model Wmodel_Trace1338_Auto_2532::MIPI_DSI1_DATA2_P W MODELTYPE=RLGC N=1
+ Lo=
+ 3.32029740e-07
+ Co=
+ 1.03489020e-10
+ Ro=
+ 3.96831067e+00
+ Go=
+ 0.00000000e+00
+ Rs=
+ 1.55902417e-03
+ Gd=
+ 2.04067990e-11

.Model Wmodel_Trace1338_Auto_2536::MIPI_DSI1_DATA2_P W MODELTYPE=RLGC N=4
+ Lo=
+ 3.30703154e-07
+ 4.20517162e-08 3.30327679e-07
+ 8.66014976e-09 2.49479336e-08 3.30321165e-07
+ 4.23249333e-09 8.67001509e-09 4.21433953e-08 3.30696443e-07
+ Co=
+ 1.03812078e-10
+ -4.50862601e-12 1.03880107e-10
+ -4.10927083e-13 -2.02521649e-12 1.03882239e-10
+ -1.91024633e-13 -4.11291921e-13 -4.52417836e-12 1.03814229e-10
+ Ro=
+ 3.96831067e+00
+ 0.00000000e+00 3.96831067e+00
+ 0.00000000e+00 0.00000000e+00 3.96831067e+00
+ 0.00000000e+00 0.00000000e+00 0.00000000e+00 3.96831067e+00
+ Go=
+ 0.00000000e+00
+ -0.00000000e+00 0.00000000e+00
+ -0.00000000e+00 -0.00000000e+00 0.00000000e+00
+ -0.00000000e+00 -0.00000000e+00 -0.00000000e+00 0.00000000e+00
+ Rs=
+ 1.55902417e-03
+ -0.00000000e+00 1.55902417e-03
+ -0.00000000e+00 -0.00000000e+00 1.55902417e-03
+ -0.00000000e+00 -0.00000000e+00 -0.00000000e+00 1.55902417e-03
+ Gd=
+ 2.03821514e-11
+ -1.77789533e-13 2.03727014e-11
+ -0.00000000e+00 -0.00000000e+00 2.03726491e-11
+ -0.00000000e+00 -0.00000000e+00 -1.79353899e-13 2.03820963e-11

.Model Wmodel_Trace1338_Auto_2554::MIPI_DSI1_DATA2_P W MODELTYPE=RLGC N=4
+ Lo=
+ 3.30718967e-07
+ 4.18275130e-08 3.30336353e-07
+ 8.67947264e-09 2.51466503e-08 3.30322241e-07
+ 4.23486481e-09 8.70118215e-09 4.20273091e-08 3.30704418e-07
+ Co=
+ 1.03806928e-10
+ -4.47074842e-12 1.03876516e-10
+ -4.11935813e-13 -2.04908037e-12 1.03881123e-10
+ -1.91305837e-13 -4.12739858e-13 -4.50454984e-12 1.03811574e-10
+ Ro=
+ 3.96831067e+00
+ 0.00000000e+00 3.96831067e+00
+ 0.00000000e+00 0.00000000e+00 3.96831067e+00
+ 0.00000000e+00 0.00000000e+00 0.00000000e+00 3.96831067e+00
+ Go=
+ 0.00000000e+00
+ -0.00000000e+00 0.00000000e+00
+ -0.00000000e+00 -0.00000000e+00 0.00000000e+00
+ -0.00000000e+00 -0.00000000e+00 -0.00000000e+00 0.00000000e+00
+ Rs=
+ 1.55902417e-03
+ -0.00000000e+00 1.55902417e-03
+ -0.00000000e+00 -0.00000000e+00 1.55902417e-03
+ -0.00000000e+00 -0.00000000e+00 -0.00000000e+00 1.55902417e-03
+ Gd=
+ 2.03822835e-11
+ -1.74040443e-13 2.03726702e-11
+ -0.00000000e+00 -0.00000000e+00 2.03725542e-11
+ -0.00000000e+00 -0.00000000e+00 -1.77428208e-13 2.03821614e-11

.Model Wmodel_Trace1338_Auto_2555::MIPI_DSI1_DATA2_P W MODELTYPE=RLGC N=1
+ Lo=
+ 3.32029740e-07
+ Co=
+ 1.03489020e-10
+ Ro=
+ 3.96831067e+00
+ Go=
+ 0.00000000e+00
+ Rs=
+ 1.55902417e-03
+ Gd=
+ 2.04067990e-11

.Model Wmodel_Trace1338_Auto_2595::MIPI_DSI1_DATA2_P W MODELTYPE=RLGC N=4
+ Lo=
+ 3.30718968e-07
+ 4.18275100e-08 3.30336364e-07
+ 8.67941396e-09 2.51463810e-08 3.30322252e-07
+ 4.23484496e-09 8.70112383e-09 4.20273115e-08 3.30704419e-07
+ Co=
+ 1.03806927e-10
+ -4.47074782e-12 1.03876514e-10
+ -4.11933423e-13 -2.04904806e-12 1.03881121e-10
+ -1.91305009e-13 -4.12737482e-13 -4.50455015e-12 1.03811574e-10
+ Ro=
+ 3.96831067e+00
+ 0.00000000e+00 3.96831067e+00
+ 0.00000000e+00 0.00000000e+00 3.96831067e+00
+ 0.00000000e+00 0.00000000e+00 0.00000000e+00 3.96831067e+00
+ Go=
+ 0.00000000e+00
+ -0.00000000e+00 0.00000000e+00
+ -0.00000000e+00 -0.00000000e+00 0.00000000e+00
+ -0.00000000e+00 -0.00000000e+00 -0.00000000e+00 0.00000000e+00
+ Rs=
+ 1.55902417e-03
+ -0.00000000e+00 1.55902417e-03
+ -0.00000000e+00 -0.00000000e+00 1.55902417e-03
+ -0.00000000e+00 -0.00000000e+00 -0.00000000e+00 1.55902417e-03
+ Gd=
+ 2.03822836e-11
+ -1.74040315e-13 2.03726704e-11
+ -0.00000000e+00 -0.00000000e+00 2.03725544e-11
+ -0.00000000e+00 -0.00000000e+00 -1.77428171e-13 2.03821614e-11

.Model Wmodel_Trace1338_Auto_2596::MIPI_DSI1_DATA2_P W MODELTYPE=RLGC N=1
+ Lo=
+ 3.32029740e-07
+ Co=
+ 1.03489020e-10
+ Ro=
+ 3.96831067e+00
+ Go=
+ 0.00000000e+00
+ Rs=
+ 1.55902417e-03
+ Gd=
+ 2.04067990e-11

.Model Wmodel_Trace1338_Auto_2601::MIPI_DSI1_DATA2_P W MODELTYPE=RLGC N=4
+ Lo=
+ 3.30718968e-07
+ 4.18275100e-08 3.30336364e-07
+ 8.67941396e-09 2.51463810e-08 3.30322252e-07
+ 4.23484496e-09 8.70112383e-09 4.20273115e-08 3.30704419e-07
+ Co=
+ 1.03806927e-10
+ -4.47074782e-12 1.03876514e-10
+ -4.11933423e-13 -2.04904806e-12 1.03881121e-10
+ -1.91305009e-13 -4.12737482e-13 -4.50455015e-12 1.03811574e-10
+ Ro=
+ 3.96831067e+00
+ 0.00000000e+00 3.96831067e+00
+ 0.00000000e+00 0.00000000e+00 3.96831067e+00
+ 0.00000000e+00 0.00000000e+00 0.00000000e+00 3.96831067e+00
+ Go=
+ 0.00000000e+00
+ -0.00000000e+00 0.00000000e+00
+ -0.00000000e+00 -0.00000000e+00 0.00000000e+00
+ -0.00000000e+00 -0.00000000e+00 -0.00000000e+00 0.00000000e+00
+ Rs=
+ 1.55902417e-03
+ -0.00000000e+00 1.55902417e-03
+ -0.00000000e+00 -0.00000000e+00 1.55902417e-03
+ -0.00000000e+00 -0.00000000e+00 -0.00000000e+00 1.55902417e-03
+ Gd=
+ 2.03822836e-11
+ -1.74040315e-13 2.03726704e-11
+ -0.00000000e+00 -0.00000000e+00 2.03725544e-11
+ -0.00000000e+00 -0.00000000e+00 -1.77428171e-13 2.03821614e-11

.Model Wmodel_Trace1338_Auto_2602::MIPI_DSI1_DATA2_P W MODELTYPE=RLGC N=1
+ Lo=
+ 3.32029740e-07
+ Co=
+ 1.03489020e-10
+ Ro=
+ 3.96831067e+00
+ Go=
+ 0.00000000e+00
+ Rs=
+ 1.55902417e-03
+ Gd=
+ 2.04067990e-11

.Model Wmodel_Trace1338_Auto_2607::MIPI_DSI1_DATA2_P W MODELTYPE=RLGC N=4
+ Lo=
+ 3.30718968e-07
+ 4.18275100e-08 3.30336364e-07
+ 8.67941396e-09 2.51463810e-08 3.30322252e-07
+ 4.23484496e-09 8.70112383e-09 4.20273115e-08 3.30704419e-07
+ Co=
+ 1.03806927e-10
+ -4.47074782e-12 1.03876514e-10
+ -4.11933423e-13 -2.04904806e-12 1.03881121e-10
+ -1.91305009e-13 -4.12737482e-13 -4.50455015e-12 1.03811574e-10
+ Ro=
+ 3.96831067e+00
+ 0.00000000e+00 3.96831067e+00
+ 0.00000000e+00 0.00000000e+00 3.96831067e+00
+ 0.00000000e+00 0.00000000e+00 0.00000000e+00 3.96831067e+00
+ Go=
+ 0.00000000e+00
+ -0.00000000e+00 0.00000000e+00
+ -0.00000000e+00 -0.00000000e+00 0.00000000e+00
+ -0.00000000e+00 -0.00000000e+00 -0.00000000e+00 0.00000000e+00
+ Rs=
+ 1.55902417e-03
+ -0.00000000e+00 1.55902417e-03
+ -0.00000000e+00 -0.00000000e+00 1.55902417e-03
+ -0.00000000e+00 -0.00000000e+00 -0.00000000e+00 1.55902417e-03
+ Gd=
+ 2.03822836e-11
+ -1.74040315e-13 2.03726704e-11
+ -0.00000000e+00 -0.00000000e+00 2.03725544e-11
+ -0.00000000e+00 -0.00000000e+00 -1.77428171e-13 2.03821614e-11

.Model Wmodel_Trace1338_Auto_2608::MIPI_DSI1_DATA2_P W MODELTYPE=RLGC N=1
+ Lo=
+ 3.32029740e-07
+ Co=
+ 1.03489020e-10
+ Ro=
+ 3.96831067e+00
+ Go=
+ 0.00000000e+00
+ Rs=
+ 1.55902417e-03
+ Gd=
+ 2.04067990e-11

.Model Wmodel_Trace1338_Auto_2616::MIPI_DSI1_DATA2_P W MODELTYPE=RLGC N=6
+ Lo=
+ 3.30667058e-07
+ 4.25134762e-08 3.30311547e-07
+ 8.51902488e-09 2.41390027e-08 3.30223968e-07
+ 4.14207163e-09 8.42312466e-09 4.20986961e-08 3.28858771e-07
+ 2.51274430e-09 4.28239513e-09 1.28226930e-08 4.74258968e-08 3.28921535e-07
+ 1.65240438e-09 2.50335942e-09 5.47819708e-09 1.27801838e-08 4.17560403e-08 3.30645689e-07
+ Co=
+ 1.03823223e-10
+ -4.58744539e-12 1.03886000e-10
+ -4.03892493e-13 -1.93072319e-12 1.03891344e-10
+ -1.79534433e-13 -3.88301004e-13 -4.53429786e-12 1.04299897e-10
+ -1.08101751e-13 -1.87434634e-13 -5.49892366e-13 -5.48927953e-12 1.04286676e-10
+ -7.53641386e-14 -1.14632027e-13 -2.38714059e-13 -5.52889340e-13 -4.46977682e-12 1.03815018e-10
+ Ro=
+ 3.96831067e+00
+ 0.00000000e+00 3.96831067e+00
+ 0.00000000e+00 0.00000000e+00 3.96831067e+00
+ 0.00000000e+00 0.00000000e+00 0.00000000e+00 3.96831067e+00
+ 0.00000000e+00 0.00000000e+00 0.00000000e+00 0.00000000e+00 3.96831067e+00
+ 0.00000000e+00 0.00000000e+00 0.00000000e+00 0.00000000e+00 0.00000000e+00 3.96831067e+00
+ Go=
+ 0.00000000e+00
+ -0.00000000e+00 0.00000000e+00
+ -0.00000000e+00 -0.00000000e+00 0.00000000e+00
+ -0.00000000e+00 -0.00000000e+00 -0.00000000e+00 0.00000000e+00
+ -0.00000000e+00 -0.00000000e+00 -0.00000000e+00 -0.00000000e+00 0.00000000e+00
+ -0.00000000e+00 -0.00000000e+00 -0.00000000e+00 -0.00000000e+00 -0.00000000e+00 0.00000000e+00
+ Rs=
+ 1.55902417e-03
+ -0.00000000e+00 1.55902417e-03
+ -0.00000000e+00 -0.00000000e+00 1.55902417e-03
+ -0.00000000e+00 -0.00000000e+00 -0.00000000e+00 1.55902417e-03
+ -0.00000000e+00 -0.00000000e+00 -0.00000000e+00 -0.00000000e+00 1.55902417e-03
+ -0.00000000e+00 -0.00000000e+00 -0.00000000e+00 -0.00000000e+00 -0.00000000e+00 1.55902417e-03
+ Gd=
+ 2.03818486e-11
+ -1.85689141e-13 2.03729435e-11
+ -0.00000000e+00 -0.00000000e+00 2.03722204e-11
+ -0.00000000e+00 -0.00000000e+00 -1.90474541e-13 2.03562864e-11
+ -0.00000000e+00 -0.00000000e+00 -0.00000000e+00 -2.95666025e-13 2.03568833e-11
+ -0.00000000e+00 -0.00000000e+00 -0.00000000e+00 -0.00000000e+00 -1.80572655e-13 2.03817726e-11

.Model Wmodel_Trace1340::MIPI_DSI1_DATA2_P W MODELTYPE=RLGC N=1
+ Lo=
+ 3.32029740e-07
+ Co=
+ 1.03489020e-10
+ Ro=
+ 3.96831067e+00
+ Go=
+ 0.00000000e+00
+ Rs=
+ 1.55902417e-03
+ Gd=
+ 2.04067990e-11

.Model Wmodel_Trace1342_Auto_2468::MIPI_DSI1_DATA2_P W MODELTYPE=RLGC N=3
+ Lo=
+ 3.30717701e-07
+ 4.20583508e-08 3.30445525e-07
+ 8.19878537e-09 2.27141863e-08 3.31689875e-07
+ Co=
+ 1.03810411e-10
+ -4.50766310e-12 1.03859395e-10
+ -4.00962233e-13 -1.77370759e-12 1.03545386e-10
+ Ro=
+ 3.96831067e+00
+ 0.00000000e+00 3.96831067e+00
+ 0.00000000e+00 0.00000000e+00 3.96831067e+00
+ Go=
+ 0.00000000e+00
+ -0.00000000e+00 0.00000000e+00
+ -0.00000000e+00 -0.00000000e+00 0.00000000e+00
+ Rs=
+ 1.55902417e-03
+ -0.00000000e+00 1.55902417e-03
+ -0.00000000e+00 -0.00000000e+00 1.55902417e-03
+ Gd=
+ 2.03823031e-11
+ -1.76792486e-13 2.03750173e-11
+ -0.00000000e+00 -0.00000000e+00 2.03982605e-11

.Model Wmodel_Trace1342_Auto_2469::MIPI_DSI1_DATA2_P W MODELTYPE=RLGC N=2
+ Lo=
+ 3.30749474e-07
+ 4.21514791e-08 3.30749474e-07
+ Co=
+ 1.03807531e-10
+ -4.51921379e-12 1.03807531e-10
+ Ro=
+ 3.96831067e+00
+ 0.00000000e+00 3.96831067e+00
+ Go=
+ 0.00000000e+00
+ -0.00000000e+00 0.00000000e+00
+ Rs=
+ 1.55902417e-03
+ -0.00000000e+00 1.55902417e-03
+ Gd=
+ 2.03827308e-11
+ -1.74962538e-13 2.03827308e-11

.Model Wmodel_Trace1342_Auto_2470::MIPI_DSI1_DATA2_P W MODELTYPE=RLGC N=1
+ Lo=
+ 3.32029740e-07
+ Co=
+ 1.03489020e-10
+ Ro=
+ 3.96831067e+00
+ Go=
+ 0.00000000e+00
+ Rs=
+ 1.55902417e-03
+ Gd=
+ 2.04067990e-11

.Model Wmodel_Trace1342_Auto_2526::MIPI_DSI1_DATA2_P W MODELTYPE=RLGC N=1
+ Lo=
+ 3.32029740e-07
+ Co=
+ 1.03489020e-10
+ Ro=
+ 3.96831067e+00
+ Go=
+ 0.00000000e+00
+ Rs=
+ 1.55902417e-03
+ Gd=
+ 2.04067990e-11

.Model Wmodel_Trace1343::MIPI_DSI1_DATA2_P W MODELTYPE=RLGC N=1
+ Lo=
+ 3.32029740e-07
+ Co=
+ 1.03489020e-10
+ Ro=
+ 3.96831067e+00
+ Go=
+ 0.00000000e+00
+ Rs=
+ 1.55902417e-03
+ Gd=
+ 2.04067990e-11

.Model Wmodel_Trace1343_Auto_2181::MIPI_DSI1_DATA2_P W MODELTYPE=RLGC N=3
+ Lo=
+ 3.30719926e-07
+ 4.20747683e-08 3.30486461e-07
+ 7.87268251e-09 2.13074609e-08 3.31734444e-07
+ Co=
+ 1.03810354e-10
+ -4.51004330e-12 1.03851217e-10
+ -3.86829753e-13 -1.62038391e-12 1.03536677e-10
+ Ro=
+ 3.96831067e+00
+ 0.00000000e+00 3.96831067e+00
+ 0.00000000e+00 0.00000000e+00 3.96831067e+00
+ Go=
+ 0.00000000e+00
+ -0.00000000e+00 0.00000000e+00
+ -0.00000000e+00 -0.00000000e+00 0.00000000e+00
+ Rs=
+ 1.55902417e-03
+ -0.00000000e+00 1.55902417e-03
+ -0.00000000e+00 -0.00000000e+00 1.55902417e-03
+ Gd=
+ 2.03823257e-11
+ -1.76720980e-13 2.03760238e-11
+ -0.00000000e+00 -0.00000000e+00 2.03993385e-11

.Model Wmodel_Trace1344::MIPI_DSI1_DATA2_P W MODELTYPE=RLGC N=1
+ Lo=
+ 3.32029740e-07
+ Co=
+ 1.03489020e-10
+ Ro=
+ 3.96831067e+00
+ Go=
+ 0.00000000e+00
+ Rs=
+ 1.55902417e-03
+ Gd=
+ 2.04067990e-11

.Model Wmodel_Trace1345::MIPI_DSI1_DATA2_P W MODELTYPE=RLGC N=1
+ Lo=
+ 3.32029740e-07
+ Co=
+ 1.03489020e-10
+ Ro=
+ 3.96831067e+00
+ Go=
+ 0.00000000e+00
+ Rs=
+ 1.55902417e-03
+ Gd=
+ 2.04067990e-11

.Model Wmodel_Trace1345_Auto_2196::MIPI_DSI1_DATA2_P W MODELTYPE=RLGC N=1
+ Lo=
+ 3.32029740e-07
+ Co=
+ 1.03489020e-10
+ Ro=
+ 3.96831067e+00
+ Go=
+ 0.00000000e+00
+ Rs=
+ 1.55902417e-03
+ Gd=
+ 2.04067990e-11

.Model Wmodel_Trace1348::MIPI_DSI1_DATA1_N W MODELTYPE=RLGC N=1
+ Lo=
+ 3.58484574e-07
+ Co=
+ 9.37055974e-11
+ Ro=
+ 4.84133902e+00
+ Go=
+ 0.00000000e+00
+ Rs=
+ 1.72420198e-03
+ Gd=
+ 1.82370500e-11

.Model Wmodel_Trace1350::MIPI_DSI1_DATA1_N W MODELTYPE=RLGC N=1
+ Lo=
+ 3.58484574e-07
+ Co=
+ 9.37055974e-11
+ Ro=
+ 4.84133902e+00
+ Go=
+ 0.00000000e+00
+ Rs=
+ 1.72420198e-03
+ Gd=
+ 1.82370500e-11

.Model Wmodel_Trace1351_Auto_899::MIPI_DSI1_DATA1_N W MODELTYPE=RLGC N=1
+ Lo=
+ 3.32029740e-07
+ Co=
+ 1.03489020e-10
+ Ro=
+ 3.96831067e+00
+ Go=
+ 0.00000000e+00
+ Rs=
+ 1.55902417e-03
+ Gd=
+ 2.04067990e-11

.Model Wmodel_Trace1351_Auto_915::MIPI_DSI1_DATA1_N W MODELTYPE=RLGC N=1
+ Lo=
+ 3.32029740e-07
+ Co=
+ 1.03489020e-10
+ Ro=
+ 3.96831067e+00
+ Go=
+ 0.00000000e+00
+ Rs=
+ 1.55902417e-03
+ Gd=
+ 2.04067990e-11

.Model Wmodel_Trace1353::MIPI_DSI1_DATA1_N W MODELTYPE=RLGC N=1
+ Lo=
+ 3.32029740e-07
+ Co=
+ 1.03489020e-10
+ Ro=
+ 3.96831067e+00
+ Go=
+ 0.00000000e+00
+ Rs=
+ 1.55902417e-03
+ Gd=
+ 2.04067990e-11

.Model Wmodel_Trace1355::MIPI_DSI1_DATA1_N W MODELTYPE=RLGC N=3
+ Lo=
+ 3.29511748e-07
+ 5.46615994e-08 3.28357979e-07
+ 1.39806269e-08 4.17151137e-08 3.30644549e-07
+ Co=
+ 1.04227008e-10
+ -6.87052906e-12 1.04531199e-10
+ -5.99462437e-13 -4.46327830e-12 1.03814752e-10
+ Ro=
+ 3.96831067e+00
+ 0.00000000e+00 3.96831067e+00
+ 0.00000000e+00 0.00000000e+00 3.96831067e+00
+ Go=
+ 0.00000000e+00
+ -0.00000000e+00 0.00000000e+00
+ -0.00000000e+00 -0.00000000e+00 0.00000000e+00
+ Rs=
+ 1.55902417e-03
+ -0.00000000e+00 1.55902417e-03
+ -0.00000000e+00 -0.00000000e+00 1.55902417e-03
+ Gd=
+ 2.03813601e-11
+ -4.48078073e-13 2.03597117e-11
+ -0.00000000e+00 -1.81351049e-13 2.03819024e-11

.Model Wmodel_Trace1356::MIPI_DSI1_DATA1_N W MODELTYPE=RLGC N=1
+ Lo=
+ 3.32029740e-07
+ Co=
+ 1.03489020e-10
+ Ro=
+ 3.96831067e+00
+ Go=
+ 0.00000000e+00
+ Rs=
+ 1.55902417e-03
+ Gd=
+ 2.04067990e-11

.Model Wmodel_Trace1357::MIPI_DSI1_DATA1_N W MODELTYPE=RLGC N=1
+ Lo=
+ 3.32029740e-07
+ Co=
+ 1.03489020e-10
+ Ro=
+ 3.96831067e+00
+ Go=
+ 0.00000000e+00
+ Rs=
+ 1.55902417e-03
+ Gd=
+ 2.04067990e-11

.Model Wmodel_Trace1357_Auto_1786::MIPI_DSI1_DATA1_N W MODELTYPE=RLGC N=5
+ Lo=
+ 3.30427661e-07
+ 4.48794673e-08 3.29206701e-07
+ 1.23745767e-08 4.16847408e-08 3.30162020e-07
+ 4.44447062e-09 9.04130965e-09 2.71701823e-08 3.30231882e-07
+ 2.58429906e-09 4.33727278e-09 9.12225564e-09 4.20033727e-08 3.30696934e-07
+ Co=
+ 1.03891031e-10
+ -5.00793039e-12 1.04201036e-10
+ -5.48343732e-13 -4.46007046e-12 1.03904421e-10
+ -2.00321643e-13 -4.15196930e-13 -2.29969726e-12 1.03899726e-10
+ -1.15947724e-13 -1.89014903e-13 -4.28997827e-13 -4.50168860e-12 1.03812140e-10
+ Ro=
+ 3.96831067e+00
+ 0.00000000e+00 3.96831067e+00
+ 0.00000000e+00 0.00000000e+00 3.96831067e+00
+ 0.00000000e+00 0.00000000e+00 0.00000000e+00 3.96831067e+00
+ 0.00000000e+00 0.00000000e+00 0.00000000e+00 0.00000000e+00 3.96831067e+00
+ Go=
+ 0.00000000e+00
+ -0.00000000e+00 0.00000000e+00
+ -0.00000000e+00 -0.00000000e+00 0.00000000e+00
+ -0.00000000e+00 -0.00000000e+00 -0.00000000e+00 0.00000000e+00
+ -0.00000000e+00 -0.00000000e+00 -0.00000000e+00 -0.00000000e+00 0.00000000e+00
+ Rs=
+ 1.55902417e-03
+ -0.00000000e+00 1.55902417e-03
+ -0.00000000e+00 -0.00000000e+00 1.55902417e-03
+ -0.00000000e+00 -0.00000000e+00 -0.00000000e+00 1.55902417e-03
+ -0.00000000e+00 -0.00000000e+00 -0.00000000e+00 -0.00000000e+00 1.55902417e-03
+ Gd=
+ 2.03803307e-11
+ -2.34438140e-13 2.03578144e-11
+ -0.00000000e+00 -1.82284269e-13 2.03701214e-11
+ -0.00000000e+00 -0.00000000e+00 -6.36032089e-15 2.03707149e-11
+ -0.00000000e+00 -0.00000000e+00 -0.00000000e+00 -1.77769359e-13 2.03820877e-11

.Model Wmodel_Trace1359::MIPI_DSI1_DATA1_N W MODELTYPE=RLGC N=1
+ Lo=
+ 3.32029740e-07
+ Co=
+ 1.03489020e-10
+ Ro=
+ 3.96831067e+00
+ Go=
+ 0.00000000e+00
+ Rs=
+ 1.55902417e-03
+ Gd=
+ 2.04067990e-11

.Model Wmodel_Trace1360::MIPI_DSI1_DATA1_N W MODELTYPE=RLGC N=5
+ Lo=
+ 3.29794994e-07
+ 5.18008763e-08 3.28597594e-07
+ 1.34719315e-08 4.15870990e-08 3.30140686e-07
+ 4.68333058e-09 9.04399320e-09 2.72830578e-08 3.30226003e-07
+ 2.68663678e-09 4.33537445e-09 9.14471970e-09 4.20017894e-08 3.30696441e-07
+ Co=
+ 1.04114935e-10
+ -6.30282390e-12 1.04422420e-10
+ -5.79196421e-13 -4.44746040e-12 1.03906202e-10
+ -2.05913653e-13 -4.12334468e-13 -2.31433052e-12 1.03900878e-10
+ -1.17916635e-13 -1.87289723e-13 -4.29866585e-13 -4.50152317e-12 1.03812168e-10
+ Ro=
+ 3.96831067e+00
+ 0.00000000e+00 3.96831067e+00
+ 0.00000000e+00 0.00000000e+00 3.96831067e+00
+ 0.00000000e+00 0.00000000e+00 0.00000000e+00 3.96831067e+00
+ 0.00000000e+00 0.00000000e+00 0.00000000e+00 0.00000000e+00 3.96831067e+00
+ Go=
+ 0.00000000e+00
+ -0.00000000e+00 0.00000000e+00
+ -0.00000000e+00 -0.00000000e+00 0.00000000e+00
+ -0.00000000e+00 -0.00000000e+00 -0.00000000e+00 0.00000000e+00
+ -0.00000000e+00 -0.00000000e+00 -0.00000000e+00 -0.00000000e+00 0.00000000e+00
+ Rs=
+ 1.55902417e-03
+ -0.00000000e+00 1.55902417e-03
+ -0.00000000e+00 -0.00000000e+00 1.55902417e-03
+ -0.00000000e+00 -0.00000000e+00 -0.00000000e+00 1.55902417e-03
+ -0.00000000e+00 -0.00000000e+00 -0.00000000e+00 -0.00000000e+00 1.55902417e-03
+ Gd=
+ 2.03798172e-11
+ -3.80518504e-13 2.03576643e-11
+ -0.00000000e+00 -1.83113686e-13 2.03699651e-11
+ -0.00000000e+00 -0.00000000e+00 -7.23152687e-15 2.03706103e-11
+ -0.00000000e+00 -0.00000000e+00 -0.00000000e+00 -1.77786986e-13 2.03820850e-11

.Model Wmodel_Trace1363::MIPI_DSI1_DATA1_N W MODELTYPE=RLGC N=1
+ Lo=
+ 3.32029740e-07
+ Co=
+ 1.03489020e-10
+ Ro=
+ 3.96831067e+00
+ Go=
+ 0.00000000e+00
+ Rs=
+ 1.55902417e-03
+ Gd=
+ 2.04067990e-11

.Model Wmodel_Trace1374::MIPI_DSI1_DATA1_N W MODELTYPE=RLGC N=1
+ Lo=
+ 3.32029740e-07
+ Co=
+ 1.03489020e-10
+ Ro=
+ 3.96831067e+00
+ Go=
+ 0.00000000e+00
+ Rs=
+ 1.55902417e-03
+ Gd=
+ 2.04067990e-11

.Model Wmodel_Trace1376_Auto_115::MIPI_DSI1_DATA1_N W MODELTYPE=RLGC N=2
+ Lo=
+ 3.31051409e-07
+ 3.76162994e-08 3.31051409e-07
+ Co=
+ 1.03713897e-10
+ -3.77996421e-12 1.03713897e-10
+ Ro=
+ 3.96831067e+00
+ 0.00000000e+00 3.96831067e+00
+ Go=
+ 0.00000000e+00
+ -0.00000000e+00 0.00000000e+00
+ Rs=
+ 1.55902417e-03
+ -0.00000000e+00 1.55902417e-03
+ Gd=
+ 2.03859622e-11
+ -1.04649610e-13 2.03859622e-11

.Model Wmodel_Trace1376_Auto_116::MIPI_DSI1_DATA1_N W MODELTYPE=RLGC N=1
+ Lo=
+ 3.32029740e-07
+ Co=
+ 1.03489020e-10
+ Ro=
+ 3.96831067e+00
+ Go=
+ 0.00000000e+00
+ Rs=
+ 1.55902417e-03
+ Gd=
+ 2.04067990e-11

.Model Wmodel_Trace1380::MIPI_DSI1_DATA1_N W MODELTYPE=RLGC N=1
+ Lo=
+ 3.32029740e-07
+ Co=
+ 1.03489020e-10
+ Ro=
+ 3.96831067e+00
+ Go=
+ 0.00000000e+00
+ Rs=
+ 1.55902417e-03
+ Gd=
+ 2.04067990e-11

.Model Wmodel_Trace1382::MIPI_DSI1_DATA1_N W MODELTYPE=RLGC N=5
+ Lo=
+ 3.29604198e-07
+ 5.36504114e-08 3.28413406e-07
+ 1.37535504e-08 4.15592981e-08 3.30136171e-07
+ 4.74074873e-09 9.03806579e-09 2.72820310e-08 3.30225762e-07
+ 2.71090471e-09 4.33270642e-09 9.14424068e-09 4.20016758e-08 3.30696388e-07
+ Co=
+ 1.04187211e-10
+ -6.66950098e-12 1.04494011e-10
+ -5.86497306e-13 -4.44394775e-12 1.03906370e-10
+ -2.07068753e-13 -4.11286391e-13 -2.31428699e-12 1.03900888e-10
+ -1.18281673e-13 -1.86729190e-13 -4.29843435e-13 -4.50151862e-12 1.03812170e-10
+ Ro=
+ 3.96831067e+00
+ 0.00000000e+00 3.96831067e+00
+ 0.00000000e+00 0.00000000e+00 3.96831067e+00
+ 0.00000000e+00 0.00000000e+00 0.00000000e+00 3.96831067e+00
+ 0.00000000e+00 0.00000000e+00 0.00000000e+00 0.00000000e+00 3.96831067e+00
+ Go=
+ 0.00000000e+00
+ -0.00000000e+00 0.00000000e+00
+ -0.00000000e+00 -0.00000000e+00 0.00000000e+00
+ -0.00000000e+00 -0.00000000e+00 -0.00000000e+00 0.00000000e+00
+ -0.00000000e+00 -0.00000000e+00 -0.00000000e+00 -0.00000000e+00 0.00000000e+00
+ Rs=
+ 1.55902417e-03
+ -0.00000000e+00 1.55902417e-03
+ -0.00000000e+00 -0.00000000e+00 1.55902417e-03
+ -0.00000000e+00 -0.00000000e+00 -0.00000000e+00 1.55902417e-03
+ -0.00000000e+00 -0.00000000e+00 -0.00000000e+00 -0.00000000e+00 1.55902417e-03
+ Gd=
+ 2.03806018e-11
+ -4.24251837e-13 2.03585448e-11
+ -0.00000000e+00 -1.83319619e-13 2.03699527e-11
+ -0.00000000e+00 -0.00000000e+00 -7.23459004e-15 2.03706098e-11
+ -0.00000000e+00 -0.00000000e+00 -0.00000000e+00 -1.77787186e-13 2.03820849e-11

.Model Wmodel_Trace1383::MIPI_DSI1_DATA1_N W MODELTYPE=RLGC N=5
+ Lo=
+ 3.29795051e-07
+ 5.18003050e-08 3.28597649e-07
+ 1.34718438e-08 4.15871074e-08 3.30140687e-07
+ 4.68331259e-09 9.04399502e-09 2.72830582e-08 3.30226003e-07
+ 2.68662916e-09 4.33537527e-09 9.14471985e-09 4.20017894e-08 3.30696441e-07
+ Co=
+ 1.04114914e-10
+ -6.30271196e-12 1.04422399e-10
+ -5.79194108e-13 -4.44746147e-12 1.03906202e-10
+ -2.05913281e-13 -4.12334790e-13 -2.31433053e-12 1.03900878e-10
+ -1.17916516e-13 -1.87289896e-13 -4.29866592e-13 -4.50152317e-12 1.03812168e-10
+ Ro=
+ 3.96831067e+00
+ 0.00000000e+00 3.96831067e+00
+ 0.00000000e+00 0.00000000e+00 3.96831067e+00
+ 0.00000000e+00 0.00000000e+00 0.00000000e+00 3.96831067e+00
+ 0.00000000e+00 0.00000000e+00 0.00000000e+00 0.00000000e+00 3.96831067e+00
+ Go=
+ 0.00000000e+00
+ -0.00000000e+00 0.00000000e+00
+ -0.00000000e+00 -0.00000000e+00 0.00000000e+00
+ -0.00000000e+00 -0.00000000e+00 -0.00000000e+00 0.00000000e+00
+ -0.00000000e+00 -0.00000000e+00 -0.00000000e+00 -0.00000000e+00 0.00000000e+00
+ Rs=
+ 1.55902417e-03
+ -0.00000000e+00 1.55902417e-03
+ -0.00000000e+00 -0.00000000e+00 1.55902417e-03
+ -0.00000000e+00 -0.00000000e+00 -0.00000000e+00 1.55902417e-03
+ -0.00000000e+00 -0.00000000e+00 -0.00000000e+00 -0.00000000e+00 1.55902417e-03
+ Gd=
+ 2.03798170e-11
+ -3.80505292e-13 2.03576641e-11
+ -0.00000000e+00 -1.83113622e-13 2.03699651e-11
+ -0.00000000e+00 -0.00000000e+00 -7.23152589e-15 2.03706103e-11
+ -0.00000000e+00 -0.00000000e+00 -0.00000000e+00 -1.77786986e-13 2.03820850e-11

.Model Wmodel_Trace1386::MIPI_DSI1_DATA1_N W MODELTYPE=RLGC N=1
+ Lo=
+ 3.32029740e-07
+ Co=
+ 1.03489020e-10
+ Ro=
+ 3.96831067e+00
+ Go=
+ 0.00000000e+00
+ Rs=
+ 1.55902417e-03
+ Gd=
+ 2.04067990e-11

.Model Wmodel_Trace1397::MIPI_DSI1_DATA1_N W MODELTYPE=RLGC N=1
+ Lo=
+ 3.32029740e-07
+ Co=
+ 1.03489020e-10
+ Ro=
+ 3.96831067e+00
+ Go=
+ 0.00000000e+00
+ Rs=
+ 1.55902417e-03
+ Gd=
+ 2.04067990e-11

.Model Wmodel_Trace1399_Auto_100::MIPI_DSI1_DATA1_N W MODELTYPE=RLGC N=3
+ Lo=
+ 3.30605104e-07
+ 4.28177550e-08 3.29414390e-07
+ 1.20956864e-08 4.18611577e-08 3.30674544e-07
+ Co=
+ 1.03835745e-10
+ -4.64462333e-12 1.04143588e-10
+ -5.46432160e-13 -4.48141913e-12 1.03813082e-10
+ Ro=
+ 3.96831067e+00
+ 0.00000000e+00 3.96831067e+00
+ 0.00000000e+00 0.00000000e+00 3.96831067e+00
+ Go=
+ 0.00000000e+00
+ -0.00000000e+00 0.00000000e+00
+ -0.00000000e+00 -0.00000000e+00 0.00000000e+00
+ Rs=
+ 1.55902417e-03
+ -0.00000000e+00 1.55902417e-03
+ -0.00000000e+00 -0.00000000e+00 1.55902417e-03
+ Gd=
+ 2.03814731e-11
+ -1.95875076e-13 2.03592433e-11
+ -0.00000000e+00 -1.79555653e-13 2.03820139e-11

.Model Wmodel_Trace1399_Auto_101::MIPI_DSI1_DATA1_N W MODELTYPE=RLGC N=2
+ Lo=
+ 3.31054270e-07
+ 3.75695727e-08 3.31054270e-07
+ Co=
+ 1.03713051e-10
+ -3.77264973e-12 1.03713051e-10
+ Ro=
+ 3.96831067e+00
+ 0.00000000e+00 3.96831067e+00
+ Go=
+ 0.00000000e+00
+ -0.00000000e+00 0.00000000e+00
+ Rs=
+ 1.55902417e-03
+ -0.00000000e+00 1.55902417e-03
+ Gd=
+ 2.03859999e-11
+ -1.03995941e-13 2.03859999e-11

.Model Wmodel_Trace1401::MIPI_DSI1_DATA1_N W MODELTYPE=RLGC N=1
+ Lo=
+ 3.32029740e-07
+ Co=
+ 1.03489020e-10
+ Ro=
+ 3.96831067e+00
+ Go=
+ 0.00000000e+00
+ Rs=
+ 1.55902417e-03
+ Gd=
+ 2.04067990e-11

.Model Wmodel_Trace1405::MIPI_DSI1_DATA1_N W MODELTYPE=RLGC N=5
+ Lo=
+ 3.29876820e-07
+ 5.09785241e-08 3.28676516e-07
+ 1.33452316e-08 4.15991879e-08 3.30142676e-07
+ 4.65727634e-09 9.04660176e-09 2.72835156e-08 3.30226112e-07
+ 2.67558398e-09 4.33655540e-09 9.14493427e-09 4.20018408e-08 3.30696466e-07
+ Co=
+ 1.04084568e-10
+ -6.14253933e-12 1.04392357e-10
+ -5.75828563e-13 -4.44899943e-12 1.03906125e-10
+ -2.05367473e-13 -4.12796616e-13 -2.31435052e-12 1.03900873e-10
+ -1.17739430e-13 -1.87537387e-13 -4.29876543e-13 -4.50152532e-12 1.03812167e-10
+ Ro=
+ 3.96831067e+00
+ 0.00000000e+00 3.96831067e+00
+ 0.00000000e+00 0.00000000e+00 3.96831067e+00
+ 0.00000000e+00 0.00000000e+00 0.00000000e+00 3.96831067e+00
+ 0.00000000e+00 0.00000000e+00 0.00000000e+00 0.00000000e+00 3.96831067e+00
+ Go=
+ 0.00000000e+00
+ -0.00000000e+00 0.00000000e+00
+ -0.00000000e+00 -0.00000000e+00 0.00000000e+00
+ -0.00000000e+00 -0.00000000e+00 -0.00000000e+00 0.00000000e+00
+ -0.00000000e+00 -0.00000000e+00 -0.00000000e+00 -0.00000000e+00 0.00000000e+00
+ Rs=
+ 1.55902417e-03
+ -0.00000000e+00 1.55902417e-03
+ -0.00000000e+00 -0.00000000e+00 1.55902417e-03
+ -0.00000000e+00 -0.00000000e+00 -0.00000000e+00 1.55902417e-03
+ -0.00000000e+00 -0.00000000e+00 -0.00000000e+00 -0.00000000e+00 1.55902417e-03
+ Gd=
+ 2.03796078e-11
+ -3.61692227e-13 2.03574121e-11
+ -0.00000000e+00 -1.83020476e-13 2.03699709e-11
+ -0.00000000e+00 -0.00000000e+00 -7.23009072e-15 2.03706106e-11
+ -0.00000000e+00 -0.00000000e+00 -0.00000000e+00 -1.77786884e-13 2.03820850e-11

.Model Wmodel_Trace1406::MIPI_DSI1_DATA1_N W MODELTYPE=RLGC N=5
+ Lo=
+ 3.29924823e-07
+ 5.04873153e-08 3.28722794e-07
+ 1.32691003e-08 4.16063290e-08 3.30143861e-07
+ 4.64155332e-09 9.04815196e-09 2.72837894e-08 3.30226177e-07
+ 2.66890144e-09 4.33725923e-09 9.14506291e-09 4.20018717e-08 3.30696480e-07
+ Co=
+ 1.04066936e-10
+ -6.04761222e-12 1.04374906e-10
+ -5.73779944e-13 -4.44991179e-12 1.03906079e-10
+ -2.05031242e-13 -4.13071461e-13 -2.31436267e-12 1.03900870e-10
+ -1.17628998e-13 -1.87684824e-13 -4.29882599e-13 -4.50152663e-12 1.03812167e-10
+ Ro=
+ 3.96831067e+00
+ 0.00000000e+00 3.96831067e+00
+ 0.00000000e+00 0.00000000e+00 3.96831067e+00
+ 0.00000000e+00 0.00000000e+00 0.00000000e+00 3.96831067e+00
+ 0.00000000e+00 0.00000000e+00 0.00000000e+00 0.00000000e+00 3.96831067e+00
+ Go=
+ 0.00000000e+00
+ -0.00000000e+00 0.00000000e+00
+ -0.00000000e+00 -0.00000000e+00 0.00000000e+00
+ -0.00000000e+00 -0.00000000e+00 -0.00000000e+00 0.00000000e+00
+ -0.00000000e+00 -0.00000000e+00 -0.00000000e+00 -0.00000000e+00 0.00000000e+00
+ Rs=
+ 1.55902417e-03
+ -0.00000000e+00 1.55902417e-03
+ -0.00000000e+00 -0.00000000e+00 1.55902417e-03
+ -0.00000000e+00 -0.00000000e+00 -0.00000000e+00 1.55902417e-03
+ -0.00000000e+00 -0.00000000e+00 -0.00000000e+00 -0.00000000e+00 1.55902417e-03
+ Gd=
+ 2.03795215e-11
+ -3.50631247e-13 2.03573001e-11
+ -0.00000000e+00 -1.82964325e-13 2.03699745e-11
+ -0.00000000e+00 -0.00000000e+00 -7.22920331e-15 2.03706108e-11
+ -0.00000000e+00 -0.00000000e+00 -0.00000000e+00 -1.77786819e-13 2.03820850e-11

.Model Wmodel_Trace1407::MIPI_DSI1_DATA1_N W MODELTYPE=RLGC N=3
+ Lo=
+ 3.30570323e-07
+ 4.32665104e-08 3.29381141e-07
+ 1.21706640e-08 4.18531102e-08 3.30673684e-07
+ Co=
+ 1.03846951e-10
+ -4.72224815e-12 1.04154587e-10
+ -5.48763133e-13 -4.48026061e-12 1.03813075e-10
+ Ro=
+ 3.96831067e+00
+ 0.00000000e+00 3.96831067e+00
+ 0.00000000e+00 0.00000000e+00 3.96831067e+00
+ Go=
+ 0.00000000e+00
+ -0.00000000e+00 0.00000000e+00
+ -0.00000000e+00 -0.00000000e+00 0.00000000e+00
+ Rs=
+ 1.55902417e-03
+ -0.00000000e+00 1.55902417e-03
+ -0.00000000e+00 -0.00000000e+00 1.55902417e-03
+ Gd=
+ 2.03812321e-11
+ -2.03883344e-13 2.03590263e-11
+ -0.00000000e+00 -1.79573068e-13 2.03820108e-11

.Model Wmodel_Trace1409::MIPI_DSI1_DATA1_N W MODELTYPE=RLGC N=1
+ Lo=
+ 3.32029740e-07
+ Co=
+ 1.03489020e-10
+ Ro=
+ 3.96831067e+00
+ Go=
+ 0.00000000e+00
+ Rs=
+ 1.55902417e-03
+ Gd=
+ 2.04067990e-11

.Model Wmodel_Trace1409_Auto_597::MIPI_DSI1_DATA1_N W MODELTYPE=RLGC N=1
+ Lo=
+ 3.32029740e-07
+ Co=
+ 1.03489020e-10
+ Ro=
+ 3.96831067e+00
+ Go=
+ 0.00000000e+00
+ Rs=
+ 1.55902417e-03
+ Gd=
+ 2.04067990e-11

.Model Wmodel_Trace1411::MIPI_DSI1_DATA1_N W MODELTYPE=RLGC N=1
+ Lo=
+ 3.32029740e-07
+ Co=
+ 1.03489020e-10
+ Ro=
+ 3.96831067e+00
+ Go=
+ 0.00000000e+00
+ Rs=
+ 1.55902417e-03
+ Gd=
+ 2.04067990e-11

.Model Wmodel_Trace1413::MIPI_DSI1_DATA1_N W MODELTYPE=RLGC N=1
+ Lo=
+ 3.32029740e-07
+ Co=
+ 1.03489020e-10
+ Ro=
+ 3.96831067e+00
+ Go=
+ 0.00000000e+00
+ Rs=
+ 1.55902417e-03
+ Gd=
+ 2.04067990e-11

.Model Wmodel_Trace1413_Auto_184::MIPI_DSI1_DATA1_N W MODELTYPE=RLGC N=1
+ Lo=
+ 3.32029740e-07
+ Co=
+ 1.03489020e-10
+ Ro=
+ 3.96831067e+00
+ Go=
+ 0.00000000e+00
+ Rs=
+ 1.55902417e-03
+ Gd=
+ 2.04067990e-11

.Model Wmodel_Trace1434::MIPI_DSI1_DATA1_N W MODELTYPE=RLGC N=1
+ Lo=
+ 3.32029740e-07
+ Co=
+ 1.03489020e-10
+ Ro=
+ 3.96831067e+00
+ Go=
+ 0.00000000e+00
+ Rs=
+ 1.55902417e-03
+ Gd=
+ 2.04067990e-11

.Model Wmodel_Trace1440::MIPI_DSI1_DATA1_N W MODELTYPE=RLGC N=1
+ Lo=
+ 3.32029740e-07
+ Co=
+ 1.03489020e-10
+ Ro=
+ 3.96831067e+00
+ Go=
+ 0.00000000e+00
+ Rs=
+ 1.55902417e-03
+ Gd=
+ 2.04067990e-11

.Model Wmodel_Trace1442::MIPI_DSI1_DATA1_N W MODELTYPE=RLGC N=1
+ Lo=
+ 3.32029740e-07
+ Co=
+ 1.03489020e-10
+ Ro=
+ 3.96831067e+00
+ Go=
+ 0.00000000e+00
+ Rs=
+ 1.55902417e-03
+ Gd=
+ 2.04067990e-11

.Model Wmodel_Trace1443::MIPI_DSI1_DATA1_N W MODELTYPE=RLGC N=1
+ Lo=
+ 3.32029740e-07
+ Co=
+ 1.03489020e-10
+ Ro=
+ 3.96831067e+00
+ Go=
+ 0.00000000e+00
+ Rs=
+ 1.55902417e-03
+ Gd=
+ 2.04067990e-11

.Model Wmodel_Trace1443_Auto_2547::MIPI_DSI1_DATA1_N W MODELTYPE=RLGC N=1
+ Lo=
+ 3.32029740e-07
+ Co=
+ 1.03489020e-10
+ Ro=
+ 3.96831067e+00
+ Go=
+ 0.00000000e+00
+ Rs=
+ 1.55902417e-03
+ Gd=
+ 2.04067990e-11

.Model Wmodel_Trace1445::MIPI_DSI1_DATA1_N W MODELTYPE=RLGC N=1
+ Lo=
+ 3.32029740e-07
+ Co=
+ 1.03489020e-10
+ Ro=
+ 3.96831067e+00
+ Go=
+ 0.00000000e+00
+ Rs=
+ 1.55902417e-03
+ Gd=
+ 2.04067990e-11

.Model Wmodel_Trace1447#BP0_Auto_2621::MIPI_DSI1_DATA1_N W MODELTYPE=RLGC N=1
+ Lo=
+ 3.32029740e-07
+ Co=
+ 1.03489020e-10
+ Ro=
+ 3.96831067e+00
+ Go=
+ 0.00000000e+00
+ Rs=
+ 1.55902417e-03
+ Gd=
+ 2.04067990e-11

.Model Wmodel_Trace1449_Auto_2500::MIPI_DSI1_DATA1_N W MODELTYPE=RLGC N=1
+ Lo=
+ 3.32029740e-07
+ Co=
+ 1.03489020e-10
+ Ro=
+ 3.96831067e+00
+ Go=
+ 0.00000000e+00
+ Rs=
+ 1.55902417e-03
+ Gd=
+ 2.04067990e-11

.Model Wmodel_Trace1451::MIPI_DSI1_DATA1_N W MODELTYPE=RLGC N=1
+ Lo=
+ 3.32029740e-07
+ Co=
+ 1.03489020e-10
+ Ro=
+ 3.96831067e+00
+ Go=
+ 0.00000000e+00
+ Rs=
+ 1.55902417e-03
+ Gd=
+ 2.04067990e-11

.Model Wmodel_Trace1451_Auto_2481::MIPI_DSI1_DATA1_N W MODELTYPE=RLGC N=3
+ Lo=
+ 3.30690475e-07
+ 4.19512072e-08 3.29887810e-07
+ 1.08200663e-08 3.55606942e-08 3.31100069e-07
+ Co=
+ 1.03812360e-10
+ -4.49369624e-12 1.03997845e-10
+ -5.03952326e-13 -3.46765613e-12 1.03687480e-10
+ Ro=
+ 3.96831067e+00
+ 0.00000000e+00 3.96831067e+00
+ 0.00000000e+00 0.00000000e+00 3.96831067e+00
+ Go=
+ 0.00000000e+00
+ -0.00000000e+00 0.00000000e+00
+ -0.00000000e+00 -0.00000000e+00 0.00000000e+00
+ Rs=
+ 1.55902417e-03
+ -0.00000000e+00 1.55902417e-03
+ -0.00000000e+00 -0.00000000e+00 1.55902417e-03
+ Gd=
+ 2.03820950e-11
+ -1.78682167e-13 2.03642352e-11
+ -0.00000000e+00 -8.46293335e-14 2.03868385e-11

.Model Wmodel_Trace1451_Auto_2486::MIPI_DSI1_DATA1_N W MODELTYPE=RLGC N=1
+ Lo=
+ 3.32029740e-07
+ Co=
+ 1.03489020e-10
+ Ro=
+ 3.96831067e+00
+ Go=
+ 0.00000000e+00
+ Rs=
+ 1.55902417e-03
+ Gd=
+ 2.04067990e-11

.Model Wmodel_Trace1451_Auto_2488::MIPI_DSI1_DATA1_N W MODELTYPE=RLGC N=1
+ Lo=
+ 3.32029740e-07
+ Co=
+ 1.03489020e-10
+ Ro=
+ 3.96831067e+00
+ Go=
+ 0.00000000e+00
+ Rs=
+ 1.55902417e-03
+ Gd=
+ 2.04067990e-11

.Model Wmodel_Trace1452::MIPI_DSI1_DATA1_N W MODELTYPE=RLGC N=1
+ Lo=
+ 3.32029740e-07
+ Co=
+ 1.03489020e-10
+ Ro=
+ 3.96831067e+00
+ Go=
+ 0.00000000e+00
+ Rs=
+ 1.55902417e-03
+ Gd=
+ 2.04067990e-11

.Model Wmodel_Trace1453::MIPI_DSI1_DATA1_N W MODELTYPE=RLGC N=4
+ Lo=
+ 3.30663441e-07
+ 4.18445522e-08 3.29385073e-07
+ 1.18905319e-08 4.19471432e-08 3.29385391e-07
+ 5.23337361e-09 1.18897339e-08 4.18399681e-08 3.30663783e-07
+ Co=
+ 1.03814101e-10
+ -4.48103970e-12 1.04134672e-10
+ -5.27613265e-13 -4.50766695e-12 1.04134566e-10
+ -2.32239409e-13 -5.27585945e-13 -4.48026158e-12 1.03813993e-10
+ Ro=
+ 3.96831067e+00
+ 0.00000000e+00 3.96831067e+00
+ 0.00000000e+00 0.00000000e+00 3.96831067e+00
+ 0.00000000e+00 0.00000000e+00 0.00000000e+00 3.96831067e+00
+ Go=
+ 0.00000000e+00
+ -0.00000000e+00 0.00000000e+00
+ -0.00000000e+00 -0.00000000e+00 0.00000000e+00
+ -0.00000000e+00 -0.00000000e+00 -0.00000000e+00 0.00000000e+00
+ Rs=
+ 1.55902417e-03
+ -0.00000000e+00 1.55902417e-03
+ -0.00000000e+00 -0.00000000e+00 1.55902417e-03
+ -0.00000000e+00 -0.00000000e+00 -0.00000000e+00 1.55902417e-03
+ Gd=
+ 2.03818859e-11
+ -1.79853095e-13 2.03589062e-11
+ -0.00000000e+00 -1.89750705e-13 2.03589087e-11
+ -0.00000000e+00 -0.00000000e+00 -1.79774738e-13 2.03818887e-11

.Model Wmodel_Trace1453_Auto_2514::MIPI_DSI1_DATA1_N W MODELTYPE=RLGC N=4
+ Lo=
+ 3.30921285e-07
+ 3.79854495e-08 3.29283685e-07
+ 1.18953774e-08 4.64069359e-08 3.29039598e-07
+ 5.23072226e-09 1.26337626e-08 4.17844584e-08 3.30653280e-07
+ Co=
+ 1.03733610e-10
+ -3.84796987e-12 1.04173045e-10
+ -5.26301590e-13 -5.29574631e-12 1.04251939e-10
+ -2.34757687e-13 -5.51690351e-13 -4.47297880e-12 1.03814536e-10
+ Ro=
+ 3.96831067e+00
+ 0.00000000e+00 3.96831067e+00
+ 0.00000000e+00 0.00000000e+00 3.96831067e+00
+ 0.00000000e+00 0.00000000e+00 0.00000000e+00 3.96831067e+00
+ Go=
+ 0.00000000e+00
+ -0.00000000e+00 0.00000000e+00
+ -0.00000000e+00 -0.00000000e+00 0.00000000e+00
+ -0.00000000e+00 -0.00000000e+00 -0.00000000e+00 0.00000000e+00
+ Rs=
+ 1.55902417e-03
+ -0.00000000e+00 1.55902417e-03
+ -0.00000000e+00 -0.00000000e+00 1.55902417e-03
+ -0.00000000e+00 -0.00000000e+00 -0.00000000e+00 1.55902417e-03
+ Gd=
+ 2.03845528e-11
+ -1.20072296e-13 2.03596596e-11
+ -0.00000000e+00 -2.72367866e-13 2.03572237e-11
+ -0.00000000e+00 -0.00000000e+00 -1.80380983e-13 2.03818400e-11

.Model Wmodel_Trace1453_Auto_2522::MIPI_DSI1_DATA1_N W MODELTYPE=RLGC N=1
+ Lo=
+ 3.32029740e-07
+ Co=
+ 1.03489020e-10
+ Ro=
+ 3.96831067e+00
+ Go=
+ 0.00000000e+00
+ Rs=
+ 1.55902417e-03
+ Gd=
+ 2.04067990e-11

.Model Wmodel_Trace1454::MIPI_DSI1_DATA1_N W MODELTYPE=RLGC N=1
+ Lo=
+ 3.32029740e-07
+ Co=
+ 1.03489020e-10
+ Ro=
+ 3.96831067e+00
+ Go=
+ 0.00000000e+00
+ Rs=
+ 1.55902417e-03
+ Gd=
+ 2.04067990e-11

.Model Wmodel_Trace1558::MIPI_DSI1_DATA1_P W MODELTYPE=RLGC N=1
+ Lo=
+ 3.58484574e-07
+ Co=
+ 9.37055974e-11
+ Ro=
+ 4.84133902e+00
+ Go=
+ 0.00000000e+00
+ Rs=
+ 1.72420198e-03
+ Gd=
+ 1.82370500e-11

.Model Wmodel_Trace1559_Auto_897::MIPI_DSI1_DATA1_P W MODELTYPE=RLGC N=1
+ Lo=
+ 3.32029740e-07
+ Co=
+ 1.03489020e-10
+ Ro=
+ 3.96831067e+00
+ Go=
+ 0.00000000e+00
+ Rs=
+ 1.55902417e-03
+ Gd=
+ 2.04067990e-11

.Model Wmodel_Trace1559_Auto_913::MIPI_DSI1_DATA1_P W MODELTYPE=RLGC N=1
+ Lo=
+ 3.32029740e-07
+ Co=
+ 1.03489020e-10
+ Ro=
+ 3.96831067e+00
+ Go=
+ 0.00000000e+00
+ Rs=
+ 1.55902417e-03
+ Gd=
+ 2.04067990e-11

.Model Wmodel_Trace1561::MIPI_DSI1_DATA1_P W MODELTYPE=RLGC N=1
+ Lo=
+ 3.32029740e-07
+ Co=
+ 1.03489020e-10
+ Ro=
+ 3.96831067e+00
+ Go=
+ 0.00000000e+00
+ Rs=
+ 1.55902417e-03
+ Gd=
+ 2.04067990e-11

.Model Wmodel_Trace1563::MIPI_DSI1_DATA1_P W MODELTYPE=RLGC N=1
+ Lo=
+ 3.32029740e-07
+ Co=
+ 1.03489020e-10
+ Ro=
+ 3.96831067e+00
+ Go=
+ 0.00000000e+00
+ Rs=
+ 1.55902417e-03
+ Gd=
+ 2.04067990e-11

.Model Wmodel_Trace1563_Auto_1758::MIPI_DSI1_DATA1_P W MODELTYPE=RLGC N=4
+ Lo=
+ 3.30626976e-07
+ 4.16351572e-08 3.28095683e-07
+ 1.40768914e-08 5.57957336e-08 3.28094494e-07
+ 5.82956711e-09 1.40808517e-08 4.16527744e-08 3.30625630e-07
+ Co=
+ 1.03815644e-10
+ -4.45465600e-12 1.04601012e-10
+ -5.87533924e-13 -7.13356071e-12 1.04601416e-10
+ -2.56102480e-13 -5.87660399e-13 -4.45765366e-12 1.03816061e-10
+ Ro=
+ 3.96831067e+00
+ 0.00000000e+00 3.96831067e+00
+ 0.00000000e+00 0.00000000e+00 3.96831067e+00
+ 0.00000000e+00 0.00000000e+00 0.00000000e+00 3.96831067e+00
+ Go=
+ 0.00000000e+00
+ -0.00000000e+00 0.00000000e+00
+ -0.00000000e+00 -0.00000000e+00 0.00000000e+00
+ -0.00000000e+00 -0.00000000e+00 -0.00000000e+00 0.00000000e+00
+ Rs=
+ 1.55902417e-03
+ -0.00000000e+00 1.55902417e-03
+ -0.00000000e+00 -0.00000000e+00 1.55902417e-03
+ -0.00000000e+00 -0.00000000e+00 -0.00000000e+00 1.55902417e-03
+ Gd=
+ 2.03817460e-11
+ -1.81559349e-13 2.03602127e-11
+ -0.00000000e+00 -4.89739438e-13 2.03602034e-11
+ -0.00000000e+00 -0.00000000e+00 -1.81862067e-13 2.03817352e-11

.Model Wmodel_Trace1565::MIPI_DSI1_DATA1_P W MODELTYPE=RLGC N=1
+ Lo=
+ 3.32029740e-07
+ Co=
+ 1.03489020e-10
+ Ro=
+ 3.96831067e+00
+ Go=
+ 0.00000000e+00
+ Rs=
+ 1.55902417e-03
+ Gd=
+ 2.04067990e-11

.Model Wmodel_Trace1567::MIPI_DSI1_DATA1_P W MODELTYPE=RLGC N=6
+ Lo=
+ 3.30617878e-07
+ 4.17592982e-08 3.28221537e-07
+ 1.38882246e-08 5.44376118e-08 3.28194247e-07
+ 5.74333307e-09 1.38038180e-08 4.15040330e-08 3.30118629e-07
+ 2.69337798e-09 4.72596169e-09 9.01806691e-09 2.72748133e-08 3.30222604e-07
+ 1.74744382e-09 2.69550013e-09 4.32088724e-09 9.13977573e-09 4.19996802e-08 3.30695117e-07
+ Co=
+ 1.03818507e-10
+ -4.47537497e-12 1.04546516e-10
+ -5.82232861e-13 -6.85760283e-12 1.04546697e-10
+ -2.48791336e-13 -5.73924114e-13 -4.43917084e-12 1.03907581e-10
+ -1.21985665e-13 -1.99579325e-13 -4.09372119e-13 -2.31371720e-12 1.03901160e-10
+ -7.94972724e-14 -1.13217105e-13 -1.85555014e-13 -4.29476582e-13 -4.50134215e-12 1.03812285e-10
+ Ro=
+ 3.96831067e+00
+ 0.00000000e+00 3.96831067e+00
+ 0.00000000e+00 0.00000000e+00 3.96831067e+00
+ 0.00000000e+00 0.00000000e+00 0.00000000e+00 3.96831067e+00
+ 0.00000000e+00 0.00000000e+00 0.00000000e+00 0.00000000e+00 3.96831067e+00
+ 0.00000000e+00 0.00000000e+00 0.00000000e+00 0.00000000e+00 0.00000000e+00 3.96831067e+00
+ Go=
+ 0.00000000e+00
+ -0.00000000e+00 0.00000000e+00
+ -0.00000000e+00 -0.00000000e+00 0.00000000e+00
+ -0.00000000e+00 -0.00000000e+00 -0.00000000e+00 0.00000000e+00
+ -0.00000000e+00 -0.00000000e+00 -0.00000000e+00 -0.00000000e+00 0.00000000e+00
+ -0.00000000e+00 -0.00000000e+00 -0.00000000e+00 -0.00000000e+00 -0.00000000e+00 0.00000000e+00
+ Rs=
+ 1.55902417e-03
+ -0.00000000e+00 1.55902417e-03
+ -0.00000000e+00 -0.00000000e+00 1.55902417e-03
+ -0.00000000e+00 -0.00000000e+00 -0.00000000e+00 1.55902417e-03
+ -0.00000000e+00 -0.00000000e+00 -0.00000000e+00 -0.00000000e+00 1.55902417e-03
+ -0.00000000e+00 -0.00000000e+00 -0.00000000e+00 -0.00000000e+00 -0.00000000e+00 1.55902417e-03
+ Gd=
+ 2.03816317e-11
+ -1.83378996e-13 2.03588897e-11
+ -0.00000000e+00 -4.56357909e-13 2.03585669e-11
+ -0.00000000e+00 -0.00000000e+00 -1.83769112e-13 2.03698021e-11
+ -0.00000000e+00 -0.00000000e+00 -0.00000000e+00 -7.30820302e-15 2.03705734e-11
+ -0.00000000e+00 -0.00000000e+00 -0.00000000e+00 -0.00000000e+00 -1.77811256e-13 2.03820690e-11

.Model Wmodel_Trace1571::MIPI_DSI1_DATA1_P W MODELTYPE=RLGC N=1
+ Lo=
+ 3.32029740e-07
+ Co=
+ 1.03489020e-10
+ Ro=
+ 3.96831067e+00
+ Go=
+ 0.00000000e+00
+ Rs=
+ 1.55902417e-03
+ Gd=
+ 2.04067990e-11

.Model Wmodel_Trace1573::MIPI_DSI1_DATA1_P W MODELTYPE=RLGC N=1
+ Lo=
+ 3.32029740e-07
+ Co=
+ 1.03489020e-10
+ Ro=
+ 3.96831067e+00
+ Go=
+ 0.00000000e+00
+ Rs=
+ 1.55902417e-03
+ Gd=
+ 2.04067990e-11

.Model Wmodel_Trace1573_Auto_112::MIPI_DSI1_DATA1_P W MODELTYPE=RLGC N=1
+ Lo=
+ 3.32029740e-07
+ Co=
+ 1.03489020e-10
+ Ro=
+ 3.96831067e+00
+ Go=
+ 0.00000000e+00
+ Rs=
+ 1.55902417e-03
+ Gd=
+ 2.04067990e-11

.Model Wmodel_Trace1575::MIPI_DSI1_DATA1_P W MODELTYPE=RLGC N=1
+ Lo=
+ 3.32029740e-07
+ Co=
+ 1.03489020e-10
+ Ro=
+ 3.96831067e+00
+ Go=
+ 0.00000000e+00
+ Rs=
+ 1.55902417e-03
+ Gd=
+ 2.04067990e-11

.Model Wmodel_Trace1582::MIPI_DSI1_DATA1_P W MODELTYPE=RLGC N=1
+ Lo=
+ 3.32029740e-07
+ Co=
+ 1.03489020e-10
+ Ro=
+ 3.96831067e+00
+ Go=
+ 0.00000000e+00
+ Rs=
+ 1.55902417e-03
+ Gd=
+ 2.04067990e-11

.Model Wmodel_Trace1584_Auto_94::MIPI_DSI1_DATA1_P W MODELTYPE=RLGC N=1
+ Lo=
+ 3.32029740e-07
+ Co=
+ 1.03489020e-10
+ Ro=
+ 3.96831067e+00
+ Go=
+ 0.00000000e+00
+ Rs=
+ 1.55902417e-03
+ Gd=
+ 2.04067990e-11

.Model Wmodel_Trace1584_Auto_99::MIPI_DSI1_DATA1_P W MODELTYPE=RLGC N=1
+ Lo=
+ 3.32029740e-07
+ Co=
+ 1.03489020e-10
+ Ro=
+ 3.96831067e+00
+ Go=
+ 0.00000000e+00
+ Rs=
+ 1.55902417e-03
+ Gd=
+ 2.04067990e-11

.Model Wmodel_Trace1588::MIPI_DSI1_DATA1_P W MODELTYPE=RLGC N=1
+ Lo=
+ 3.32029740e-07
+ Co=
+ 1.03489020e-10
+ Ro=
+ 3.96831067e+00
+ Go=
+ 0.00000000e+00
+ Rs=
+ 1.55902417e-03
+ Gd=
+ 2.04067990e-11

.Model Wmodel_Trace1590::MIPI_DSI1_DATA1_P W MODELTYPE=RLGC N=6
+ Lo=
+ 3.30650134e-07
+ 4.13213506e-08 3.28219340e-07
+ 1.38396797e-08 5.47472376e-08 3.28162905e-07
+ 5.72988851e-09 1.38508934e-08 4.14995299e-08 3.30117948e-07
+ 2.68921109e-09 4.73568388e-09 9.01715871e-09 2.72746709e-08 3.30222574e-07
+ 1.74533873e-09 2.69967009e-09 4.32049174e-09 9.13971241e-09 4.19996672e-08 3.30695112e-07
+ Co=
+ 1.03808346e-10
+ -4.40119293e-12 1.04549494e-10
+ -5.80555470e-13 -6.92029381e-12 1.04559557e-10
+ -2.48595105e-13 -5.75315271e-13 -4.43859060e-12 1.03907605e-10
+ -1.21953765e-13 -1.99871631e-13 -4.09202109e-13 -2.31371120e-12 1.03901162e-10
+ -7.94959624e-14 -1.13345454e-13 -1.85464694e-13 -4.29473658e-13 -4.50134158e-12 1.03812285e-10
+ Ro=
+ 3.96831067e+00
+ 0.00000000e+00 3.96831067e+00
+ 0.00000000e+00 0.00000000e+00 3.96831067e+00
+ 0.00000000e+00 0.00000000e+00 0.00000000e+00 3.96831067e+00
+ 0.00000000e+00 0.00000000e+00 0.00000000e+00 0.00000000e+00 3.96831067e+00
+ 0.00000000e+00 0.00000000e+00 0.00000000e+00 0.00000000e+00 0.00000000e+00 3.96831067e+00
+ Go=
+ 0.00000000e+00
+ -0.00000000e+00 0.00000000e+00
+ -0.00000000e+00 -0.00000000e+00 0.00000000e+00
+ -0.00000000e+00 -0.00000000e+00 -0.00000000e+00 0.00000000e+00
+ -0.00000000e+00 -0.00000000e+00 -0.00000000e+00 -0.00000000e+00 0.00000000e+00
+ -0.00000000e+00 -0.00000000e+00 -0.00000000e+00 -0.00000000e+00 -0.00000000e+00 0.00000000e+00
+ Rs=
+ 1.55902417e-03
+ -0.00000000e+00 1.55902417e-03
+ -0.00000000e+00 -0.00000000e+00 1.55902417e-03
+ -0.00000000e+00 -0.00000000e+00 -0.00000000e+00 1.55902417e-03
+ -0.00000000e+00 -0.00000000e+00 -0.00000000e+00 -0.00000000e+00 1.55902417e-03
+ -0.00000000e+00 -0.00000000e+00 -0.00000000e+00 -0.00000000e+00 -0.00000000e+00 1.55902417e-03
+ Gd=
+ 2.03818999e-11
+ -1.76000812e-13 2.03593610e-11
+ -0.00000000e+00 -4.63868425e-13 2.03588071e-11
+ -0.00000000e+00 -0.00000000e+00 -1.83801283e-13 2.03698002e-11
+ -0.00000000e+00 -0.00000000e+00 -0.00000000e+00 -7.30866951e-15 2.03705733e-11
+ -0.00000000e+00 -0.00000000e+00 -0.00000000e+00 -0.00000000e+00 -1.77811302e-13 2.03820690e-11

.Model Wmodel_Trace1594::MIPI_DSI1_DATA1_P W MODELTYPE=RLGC N=1
+ Lo=
+ 3.32029740e-07
+ Co=
+ 1.03489020e-10
+ Ro=
+ 3.96831067e+00
+ Go=
+ 0.00000000e+00
+ Rs=
+ 1.55902417e-03
+ Gd=
+ 2.04067990e-11

.Model Wmodel_Trace1596_Auto_95::MIPI_DSI1_DATA1_P W MODELTYPE=RLGC N=1
+ Lo=
+ 3.32029740e-07
+ Co=
+ 1.03489020e-10
+ Ro=
+ 3.96831067e+00
+ Go=
+ 0.00000000e+00
+ Rs=
+ 1.55902417e-03
+ Gd=
+ 2.04067990e-11

.Model Wmodel_Trace1596_Auto_96::MIPI_DSI1_DATA1_P W MODELTYPE=RLGC N=1
+ Lo=
+ 3.32029740e-07
+ Co=
+ 1.03489020e-10
+ Ro=
+ 3.96831067e+00
+ Go=
+ 0.00000000e+00
+ Rs=
+ 1.55902417e-03
+ Gd=
+ 2.04067990e-11

.Model Wmodel_Trace1605::MIPI_DSI1_DATA1_P W MODELTYPE=RLGC N=1
+ Lo=
+ 3.32029740e-07
+ Co=
+ 1.03489020e-10
+ Ro=
+ 3.96831067e+00
+ Go=
+ 0.00000000e+00
+ Rs=
+ 1.55902417e-03
+ Gd=
+ 2.04067990e-11

.Model Wmodel_Trace1607_Auto_102::MIPI_DSI1_DATA1_P W MODELTYPE=RLGC N=1
+ Lo=
+ 3.32029740e-07
+ Co=
+ 1.03489020e-10
+ Ro=
+ 3.96831067e+00
+ Go=
+ 0.00000000e+00
+ Rs=
+ 1.55902417e-03
+ Gd=
+ 2.04067990e-11

.Model Wmodel_Trace1607_Auto_103::MIPI_DSI1_DATA1_P W MODELTYPE=RLGC N=1
+ Lo=
+ 3.32029740e-07
+ Co=
+ 1.03489020e-10
+ Ro=
+ 3.96831067e+00
+ Go=
+ 0.00000000e+00
+ Rs=
+ 1.55902417e-03
+ Gd=
+ 2.04067990e-11

.Model Wmodel_Trace1607_Auto_109::MIPI_DSI1_DATA1_P W MODELTYPE=RLGC N=8
+ Lo=
+ 3.30658873e-07
+ 4.18342871e-08 3.29393773e-07
+ 1.18111459e-08 4.15697049e-08 3.29323992e-07
+ 5.15075674e-09 1.17068666e-08 4.15257191e-08 3.29323593e-07
+ 2.84466275e-09 5.09473416e-09 1.16742842e-08 4.14220686e-08 3.29364272e-07
+ 1.79642958e-09 2.80224610e-09 5.05562896e-09 1.15672569e-08 4.09140016e-08 3.29298634e-07
+ 1.24971712e-09 1.78990837e-09 2.82104527e-09 5.10903572e-09 1.17576830e-08 4.24988381e-08 3.29325687e-07
+ 9.25832773e-10 1.24973874e-09 1.80583086e-09 2.85002935e-09 5.16461211e-09 1.19689421e-08 4.18206457e-08 3.30656778e-07
+ Co=
+ 1.03814457e-10
+ -4.47996230e-12 1.04127856e-10
+ -5.24067133e-13 -4.44677451e-12 1.04132714e-10
+ -2.21826146e-13 -5.09157912e-13 -4.44184901e-12 1.04130571e-10
+ -1.23352954e-13 -2.13652649e-13 -5.07745348e-13 -4.42444372e-12 1.04116940e-10
+ -7.84504460e-14 -1.17708446e-13 -2.11817556e-13 -5.03691816e-13 -4.33872687e-12 1.04141007e-10
+ -5.48899323e-14 -7.54198356e-14 -1.18049395e-13 -2.13451477e-13 -5.10680184e-13 -4.60586055e-12 1.04149850e-10
+ -4.26382948e-14 -5.50377877e-14 -7.88041912e-14 -1.23475576e-13 -2.22787576e-13 -5.29251915e-13 -4.47809760e-12 1.03814527e-10
+ Ro=
+ 3.96831067e+00
+ 0.00000000e+00 3.96831067e+00
+ 0.00000000e+00 0.00000000e+00 3.96831067e+00
+ 0.00000000e+00 0.00000000e+00 0.00000000e+00 3.96831067e+00
+ 0.00000000e+00 0.00000000e+00 0.00000000e+00 0.00000000e+00 3.96831067e+00
+ 0.00000000e+00 0.00000000e+00 0.00000000e+00 0.00000000e+00 0.00000000e+00 3.96831067e+00
+ 0.00000000e+00 0.00000000e+00 0.00000000e+00 0.00000000e+00 0.00000000e+00 0.00000000e+00 3.96831067e+00
+ 0.00000000e+00 0.00000000e+00 0.00000000e+00 0.00000000e+00 0.00000000e+00 0.00000000e+00 0.00000000e+00 3.96831067e+00
+ Go=
+ 0.00000000e+00
+ -0.00000000e+00 0.00000000e+00
+ -0.00000000e+00 -0.00000000e+00 0.00000000e+00
+ -0.00000000e+00 -0.00000000e+00 -0.00000000e+00 0.00000000e+00
+ -0.00000000e+00 -0.00000000e+00 -0.00000000e+00 -0.00000000e+00 0.00000000e+00
+ -0.00000000e+00 -0.00000000e+00 -0.00000000e+00 -0.00000000e+00 -0.00000000e+00 0.00000000e+00
+ -0.00000000e+00 -0.00000000e+00 -0.00000000e+00 -0.00000000e+00 -0.00000000e+00 -0.00000000e+00 0.00000000e+00
+ -0.00000000e+00 -0.00000000e+00 -0.00000000e+00 -0.00000000e+00 -0.00000000e+00 -0.00000000e+00 -0.00000000e+00 0.00000000e+00
+ Rs=
+ 1.55902417e-03
+ -0.00000000e+00 1.55902417e-03
+ -0.00000000e+00 -0.00000000e+00 1.55902417e-03
+ -0.00000000e+00 -0.00000000e+00 -0.00000000e+00 1.55902417e-03
+ -0.00000000e+00 -0.00000000e+00 -0.00000000e+00 -0.00000000e+00 1.55902417e-03
+ -0.00000000e+00 -0.00000000e+00 -0.00000000e+00 -0.00000000e+00 -0.00000000e+00 1.55902417e-03
+ -0.00000000e+00 -0.00000000e+00 -0.00000000e+00 -0.00000000e+00 -0.00000000e+00 -0.00000000e+00 1.55902417e-03
+ -0.00000000e+00 -0.00000000e+00 -0.00000000e+00 -0.00000000e+00 -0.00000000e+00 -0.00000000e+00 -0.00000000e+00 1.55902417e-03
+ Gd=
+ 2.03818215e-11
+ -1.79833582e-13 2.03589286e-11
+ -0.00000000e+00 -1.84218654e-13 2.03583100e-11
+ -0.00000000e+00 -0.00000000e+00 -1.84149540e-13 2.03582870e-11
+ -0.00000000e+00 -0.00000000e+00 -0.00000000e+00 -1.82324076e-13 2.03586249e-11
+ -0.00000000e+00 -0.00000000e+00 -0.00000000e+00 -0.00000000e+00 -1.74061035e-13 2.03581644e-11
+ -0.00000000e+00 -0.00000000e+00 -0.00000000e+00 -0.00000000e+00 -0.00000000e+00 -2.00287253e-13 2.03584344e-11
+ -0.00000000e+00 -0.00000000e+00 -0.00000000e+00 -0.00000000e+00 -0.00000000e+00 -0.00000000e+00 -1.79925322e-13 2.03818113e-11

.Model Wmodel_Trace1611::MIPI_DSI1_DATA1_P W MODELTYPE=RLGC N=1
+ Lo=
+ 3.32029740e-07
+ Co=
+ 1.03489020e-10
+ Ro=
+ 3.96831067e+00
+ Go=
+ 0.00000000e+00
+ Rs=
+ 1.55902417e-03
+ Gd=
+ 2.04067990e-11

.Model Wmodel_Trace1613::MIPI_DSI1_DATA1_P W MODELTYPE=RLGC N=6
+ Lo=
+ 3.30626757e-07
+ 4.16478257e-08 3.28238166e-07
+ 1.38520386e-08 5.43601777e-08 3.28203206e-07
+ 5.73371800e-09 1.37924831e-08 4.15054434e-08 3.30118878e-07
+ 2.69037536e-09 4.72375393e-09 9.01838829e-09 2.72748762e-08 3.30222621e-07
+ 1.74590819e-09 2.69459570e-09 4.32103826e-09 9.13980687e-09 4.19996888e-08 3.30695122e-07
+ Co=
+ 1.03815821e-10
+ -4.45632008e-12 1.04540549e-10
+ -5.81221814e-13 -6.84166407e-12 1.04543330e-10
+ -2.48499779e-13 -5.73710442e-13 -4.43933286e-12 1.03907571e-10
+ -1.21895283e-13 -1.99570558e-13 -4.09420959e-13 -2.31372008e-12 1.03901159e-10
+ -7.94547906e-14 -1.13225837e-13 -1.85581264e-13 -4.29478098e-13 -4.50134257e-12 1.03812284e-10
+ Ro=
+ 3.96831067e+00
+ 0.00000000e+00 3.96831067e+00
+ 0.00000000e+00 0.00000000e+00 3.96831067e+00
+ 0.00000000e+00 0.00000000e+00 0.00000000e+00 3.96831067e+00
+ 0.00000000e+00 0.00000000e+00 0.00000000e+00 0.00000000e+00 3.96831067e+00
+ 0.00000000e+00 0.00000000e+00 0.00000000e+00 0.00000000e+00 0.00000000e+00 3.96831067e+00
+ Go=
+ 0.00000000e+00
+ -0.00000000e+00 0.00000000e+00
+ -0.00000000e+00 -0.00000000e+00 0.00000000e+00
+ -0.00000000e+00 -0.00000000e+00 -0.00000000e+00 0.00000000e+00
+ -0.00000000e+00 -0.00000000e+00 -0.00000000e+00 -0.00000000e+00 0.00000000e+00
+ -0.00000000e+00 -0.00000000e+00 -0.00000000e+00 -0.00000000e+00 -0.00000000e+00 0.00000000e+00
+ Rs=
+ 1.55902417e-03
+ -0.00000000e+00 1.55902417e-03
+ -0.00000000e+00 -0.00000000e+00 1.55902417e-03
+ -0.00000000e+00 -0.00000000e+00 -0.00000000e+00 1.55902417e-03
+ -0.00000000e+00 -0.00000000e+00 -0.00000000e+00 -0.00000000e+00 1.55902417e-03
+ -0.00000000e+00 -0.00000000e+00 -0.00000000e+00 -0.00000000e+00 -0.00000000e+00 1.55902417e-03
+ Gd=
+ 2.03817019e-11
+ -1.81427038e-13 2.03588914e-11
+ -0.00000000e+00 -4.54372302e-13 2.03585091e-11
+ -0.00000000e+00 -0.00000000e+00 -1.83759774e-13 2.03698028e-11
+ -0.00000000e+00 -0.00000000e+00 -0.00000000e+00 -7.30798086e-15 2.03705735e-11
+ -0.00000000e+00 -0.00000000e+00 -0.00000000e+00 -0.00000000e+00 -1.77811227e-13 2.03820690e-11

.Model Wmodel_Trace1615::MIPI_DSI1_DATA1_P W MODELTYPE=RLGC N=1
+ Lo=
+ 3.32029740e-07
+ Co=
+ 1.03489020e-10
+ Ro=
+ 3.96831067e+00
+ Go=
+ 0.00000000e+00
+ Rs=
+ 1.55902417e-03
+ Gd=
+ 2.04067990e-11

.Model Wmodel_Trace1617::MIPI_DSI1_DATA1_P W MODELTYPE=RLGC N=1
+ Lo=
+ 3.32029740e-07
+ Co=
+ 1.03489020e-10
+ Ro=
+ 3.96831067e+00
+ Go=
+ 0.00000000e+00
+ Rs=
+ 1.55902417e-03
+ Gd=
+ 2.04067990e-11

.Model Wmodel_Trace1617_Auto_590::MIPI_DSI1_DATA1_P W MODELTYPE=RLGC N=4
+ Lo=
+ 3.30629583e-07
+ 4.18222816e-08 3.28543957e-07
+ 1.34461900e-08 5.14613359e-08 3.28521002e-07
+ 5.68905506e-09 1.35158378e-08 4.21561294e-08 3.30604038e-07
+ Co=
+ 1.03817980e-10
+ -4.48325565e-12 1.04426357e-10
+ -5.71698006e-13 -6.25920798e-12 1.04434143e-10
+ -2.50091409e-13 -5.73962782e-13 -4.54027030e-12 1.03825976e-10
+ Ro=
+ 3.96831067e+00
+ 0.00000000e+00 3.96831067e+00
+ 0.00000000e+00 0.00000000e+00 3.96831067e+00
+ 0.00000000e+00 0.00000000e+00 0.00000000e+00 3.96831067e+00
+ Go=
+ 0.00000000e+00
+ -0.00000000e+00 0.00000000e+00
+ -0.00000000e+00 -0.00000000e+00 0.00000000e+00
+ -0.00000000e+00 -0.00000000e+00 -0.00000000e+00 0.00000000e+00
+ Rs=
+ 1.55902417e-03
+ -0.00000000e+00 1.55902417e-03
+ -0.00000000e+00 -0.00000000e+00 1.55902417e-03
+ -0.00000000e+00 -0.00000000e+00 -0.00000000e+00 1.55902417e-03
+ Gd=
+ 2.03817107e-11
+ -1.83072719e-13 2.03573838e-11
+ -0.00000000e+00 -3.84082050e-13 2.03572114e-11
+ -0.00000000e+00 -0.00000000e+00 -1.88859132e-13 2.03815110e-11

.Model Wmodel_Trace1617_Auto_601::MIPI_DSI1_DATA1_P W MODELTYPE=RLGC N=2
+ Lo=
+ 3.30748548e-07
+ 4.21643423e-08 3.30748548e-07
+ Co=
+ 1.03807831e-10
+ -4.52139172e-12 1.03807831e-10
+ Ro=
+ 3.96831067e+00
+ 0.00000000e+00 3.96831067e+00
+ Go=
+ 0.00000000e+00
+ -0.00000000e+00 0.00000000e+00
+ Rs=
+ 1.55902417e-03
+ -0.00000000e+00 1.55902417e-03
+ Gd=
+ 2.03827231e-11
+ -1.75181003e-13 2.03827231e-11

.Model Wmodel_Trace1619::MIPI_DSI1_DATA1_P W MODELTYPE=RLGC N=1
+ Lo=
+ 3.32029740e-07
+ Co=
+ 1.03489020e-10
+ Ro=
+ 3.96831067e+00
+ Go=
+ 0.00000000e+00
+ Rs=
+ 1.55902417e-03
+ Gd=
+ 2.04067990e-11

.Model Wmodel_Trace1621::MIPI_DSI1_DATA1_P W MODELTYPE=RLGC N=2
+ Lo=
+ 3.30740391e-07
+ 4.22774243e-08 3.30740391e-07
+ Co=
+ 1.03810473e-10
+ -4.54055774e-12 1.03810473e-10
+ Ro=
+ 3.96831067e+00
+ 0.00000000e+00 3.96831067e+00
+ Go=
+ 0.00000000e+00
+ -0.00000000e+00 0.00000000e+00
+ Rs=
+ 1.55902417e-03
+ -0.00000000e+00 1.55902417e-03
+ Gd=
+ 2.03826559e-11
+ -1.77106111e-13 2.03826559e-11

.Model Wmodel_Trace1625::MIPI_DSI1_DATA1_P W MODELTYPE=RLGC N=1
+ Lo=
+ 3.32029740e-07
+ Co=
+ 1.03489020e-10
+ Ro=
+ 3.96831067e+00
+ Go=
+ 0.00000000e+00
+ Rs=
+ 1.55902417e-03
+ Gd=
+ 2.04067990e-11

.Model Wmodel_Trace1636::MIPI_DSI1_DATA1_P W MODELTYPE=RLGC N=1
+ Lo=
+ 3.32029740e-07
+ Co=
+ 1.03489020e-10
+ Ro=
+ 3.96831067e+00
+ Go=
+ 0.00000000e+00
+ Rs=
+ 1.55902417e-03
+ Gd=
+ 2.04067990e-11

.Model Wmodel_Trace1647::MIPI_DSI1_DATA1_P W MODELTYPE=RLGC N=1
+ Lo=
+ 3.32029740e-07
+ Co=
+ 1.03489020e-10
+ Ro=
+ 3.96831067e+00
+ Go=
+ 0.00000000e+00
+ Rs=
+ 1.55902417e-03
+ Gd=
+ 2.04067990e-11

.Model Wmodel_Trace1649::MIPI_DSI1_DATA1_P W MODELTYPE=RLGC N=1
+ Lo=
+ 3.32029740e-07
+ Co=
+ 1.03489020e-10
+ Ro=
+ 3.96831067e+00
+ Go=
+ 0.00000000e+00
+ Rs=
+ 1.55902417e-03
+ Gd=
+ 2.04067990e-11

.Model Wmodel_Trace1658#BP0::MIPI_DSI1_DATA1_P W MODELTYPE=RLGC N=1
+ Lo=
+ 3.32029740e-07
+ Co=
+ 1.03489020e-10
+ Ro=
+ 3.96831067e+00
+ Go=
+ 0.00000000e+00
+ Rs=
+ 1.55902417e-03
+ Gd=
+ 2.04067990e-11

.Model Wmodel_Trace1660::MIPI_DSI1_DATA1_P W MODELTYPE=RLGC N=1
+ Lo=
+ 3.32029740e-07
+ Co=
+ 1.03489020e-10
+ Ro=
+ 3.96831067e+00
+ Go=
+ 0.00000000e+00
+ Rs=
+ 1.55902417e-03
+ Gd=
+ 2.04067990e-11

.Model Wmodel_Trace1660_Auto_56::MIPI_DSI1_DATA1_P W MODELTYPE=RLGC N=4
+ Lo=
+ 3.30731045e-07
+ 4.09245204e-08 3.29442901e-07
+ 1.17482518e-08 4.20497136e-08 3.29379008e-07
+ 5.19280479e-09 1.19125199e-08 4.18617688e-08 3.30662097e-07
+ Co=
+ 1.03792997e-10
+ -4.32600522e-12 1.04116082e-10
+ -5.23093480e-13 -4.52479750e-12 1.04137172e-10
+ -2.31213560e-13 -5.28749605e-13 -4.48393300e-12 1.03814520e-10
+ Ro=
+ 3.96831067e+00
+ 0.00000000e+00 3.96831067e+00
+ 0.00000000e+00 0.00000000e+00 3.96831067e+00
+ 0.00000000e+00 0.00000000e+00 0.00000000e+00 3.96831067e+00
+ Go=
+ 0.00000000e+00
+ -0.00000000e+00 0.00000000e+00
+ -0.00000000e+00 -0.00000000e+00 0.00000000e+00
+ -0.00000000e+00 -0.00000000e+00 -0.00000000e+00 0.00000000e+00
+ Rs=
+ 1.55902417e-03
+ -0.00000000e+00 1.55902417e-03
+ -0.00000000e+00 -0.00000000e+00 1.55902417e-03
+ -0.00000000e+00 -0.00000000e+00 -0.00000000e+00 1.55902417e-03
+ Gd=
+ 2.03824731e-11
+ -1.64416963e-13 2.03593935e-11
+ -0.00000000e+00 -1.91239428e-13 2.03588550e-11
+ -0.00000000e+00 -0.00000000e+00 -1.80166297e-13 2.03818748e-11

.Model Wmodel_Trace1664::MIPI_DSI1_DATA1_P W MODELTYPE=RLGC N=1
+ Lo=
+ 3.32029740e-07
+ Co=
+ 1.03489020e-10
+ Ro=
+ 3.96831067e+00
+ Go=
+ 0.00000000e+00
+ Rs=
+ 1.55902417e-03
+ Gd=
+ 2.04067990e-11

.Model Wmodel_Trace1666#BP0::MIPI_DSI1_DATA1_P W MODELTYPE=RLGC N=2
+ Lo=
+ 3.30906868e-07
+ 3.98782800e-08 3.30906868e-07
+ Co=
+ 1.03757677e-10
+ -4.14147894e-12 1.03757677e-10
+ Ro=
+ 3.96831067e+00
+ 0.00000000e+00 3.96831067e+00
+ Go=
+ 0.00000000e+00
+ -0.00000000e+00 0.00000000e+00
+ Rs=
+ 1.55902417e-03
+ -0.00000000e+00 1.55902417e-03
+ Gd=
+ 2.03842326e-11
+ -1.38032384e-13 2.03842326e-11

.Model Wmodel_Trace1666#BP0_Auto_160::MIPI_DSI1_DATA1_P W MODELTYPE=RLGC N=1
+ Lo=
+ 3.32029740e-07
+ Co=
+ 1.03489020e-10
+ Ro=
+ 3.96831067e+00
+ Go=
+ 0.00000000e+00
+ Rs=
+ 1.55902417e-03
+ Gd=
+ 2.04067990e-11

.Model Wmodel_Trace1666::MIPI_DSI1_DATA1_P W MODELTYPE=RLGC N=2
+ Lo=
+ 3.30800836e-07
+ 4.14290146e-08 3.30800836e-07
+ Co=
+ 1.03791024e-10
+ -4.39761636e-12 1.03791024e-10
+ Ro=
+ 3.96831067e+00
+ 0.00000000e+00 3.96831067e+00
+ Go=
+ 0.00000000e+00
+ -0.00000000e+00 0.00000000e+00
+ Rs=
+ 1.55902417e-03
+ -0.00000000e+00 1.55902417e-03
+ Gd=
+ 2.03831782e-11
+ -1.62862873e-13 2.03831782e-11

.Model Wmodel_Trace1666_Auto_181::MIPI_DSI1_DATA1_P W MODELTYPE=RLGC N=2
+ Lo=
+ 3.30767226e-07
+ 4.19037621e-08 3.30767226e-07
+ Co=
+ 1.03801800e-10
+ -4.47735960e-12 1.03801800e-10
+ Ro=
+ 3.96831067e+00
+ 0.00000000e+00 3.96831067e+00
+ Go=
+ 0.00000000e+00
+ -0.00000000e+00 0.00000000e+00
+ Rs=
+ 1.55902417e-03
+ -0.00000000e+00 1.55902417e-03
+ Gd=
+ 2.03828808e-11
+ -1.70776059e-13 2.03828808e-11

.Model Wmodel_Trace1666_Auto_182::MIPI_DSI1_DATA1_P W MODELTYPE=RLGC N=1
+ Lo=
+ 3.32029740e-07
+ Co=
+ 1.03489020e-10
+ Ro=
+ 3.96831067e+00
+ Go=
+ 0.00000000e+00
+ Rs=
+ 1.55902417e-03
+ Gd=
+ 2.04067990e-11

.Model Wmodel_Trace1666_Auto_186::MIPI_DSI1_DATA1_P W MODELTYPE=RLGC N=1
+ Lo=
+ 3.32029740e-07
+ Co=
+ 1.03489020e-10
+ Ro=
+ 3.96831067e+00
+ Go=
+ 0.00000000e+00
+ Rs=
+ 1.55902417e-03
+ Gd=
+ 2.04067990e-11

.Model Wmodel_Trace1668::MIPI_DSI1_DATA1_P W MODELTYPE=RLGC N=1
+ Lo=
+ 3.32029740e-07
+ Co=
+ 1.03489020e-10
+ Ro=
+ 3.96831067e+00
+ Go=
+ 0.00000000e+00
+ Rs=
+ 1.55902417e-03
+ Gd=
+ 2.04067990e-11

.Model Wmodel_Trace1672::MIPI_DSI1_DATA1_P W MODELTYPE=RLGC N=1
+ Lo=
+ 3.32029740e-07
+ Co=
+ 1.03489020e-10
+ Ro=
+ 3.96831067e+00
+ Go=
+ 0.00000000e+00
+ Rs=
+ 1.55902417e-03
+ Gd=
+ 2.04067990e-11

.Model Wmodel_Trace1673_Auto_2538::MIPI_DSI1_DATA1_P W MODELTYPE=RLGC N=1
+ Lo=
+ 3.32029740e-07
+ Co=
+ 1.03489020e-10
+ Ro=
+ 3.96831067e+00
+ Go=
+ 0.00000000e+00
+ Rs=
+ 1.55902417e-03
+ Gd=
+ 2.04067990e-11

.Model Wmodel_Trace1675::MIPI_DSI1_DATA1_P W MODELTYPE=RLGC N=1
+ Lo=
+ 3.32029740e-07
+ Co=
+ 1.03489020e-10
+ Ro=
+ 3.96831067e+00
+ Go=
+ 0.00000000e+00
+ Rs=
+ 1.55902417e-03
+ Gd=
+ 2.04067990e-11

.Model Wmodel_Trace1677::MIPI_DSI1_DATA1_P W MODELTYPE=RLGC N=1
+ Lo=
+ 3.32029740e-07
+ Co=
+ 1.03489020e-10
+ Ro=
+ 3.96831067e+00
+ Go=
+ 0.00000000e+00
+ Rs=
+ 1.55902417e-03
+ Gd=
+ 2.04067990e-11

.Model Wmodel_Trace1677_Auto_2531::MIPI_DSI1_DATA1_P W MODELTYPE=RLGC N=2
+ Lo=
+ 3.30748904e-07
+ 4.21593990e-08 3.30748904e-07
+ Co=
+ 1.03807716e-10
+ -4.52055469e-12 1.03807716e-10
+ Ro=
+ 3.96831067e+00
+ 0.00000000e+00 3.96831067e+00
+ Go=
+ 0.00000000e+00
+ -0.00000000e+00 0.00000000e+00
+ Rs=
+ 1.55902417e-03
+ -0.00000000e+00 1.55902417e-03
+ Gd=
+ 2.03827260e-11
+ -1.75097034e-13 2.03827260e-11

.Model Wmodel_Trace1677_Auto_2561::MIPI_DSI1_DATA1_P W MODELTYPE=RLGC N=2
+ Lo=
+ 3.30748904e-07
+ 4.21593990e-08 3.30748904e-07
+ Co=
+ 1.03807716e-10
+ -4.52055469e-12 1.03807716e-10
+ Ro=
+ 3.96831067e+00
+ 0.00000000e+00 3.96831067e+00
+ Go=
+ 0.00000000e+00
+ -0.00000000e+00 0.00000000e+00
+ Rs=
+ 1.55902417e-03
+ -0.00000000e+00 1.55902417e-03
+ Gd=
+ 2.03827260e-11
+ -1.75097034e-13 2.03827260e-11

.Model Wmodel_Trace1677_Auto_2565::MIPI_DSI1_DATA1_P W MODELTYPE=RLGC N=2
+ Lo=
+ 3.30748904e-07
+ 4.21593990e-08 3.30748904e-07
+ Co=
+ 1.03807716e-10
+ -4.52055469e-12 1.03807716e-10
+ Ro=
+ 3.96831067e+00
+ 0.00000000e+00 3.96831067e+00
+ Go=
+ 0.00000000e+00
+ -0.00000000e+00 0.00000000e+00
+ Rs=
+ 1.55902417e-03
+ -0.00000000e+00 1.55902417e-03
+ Gd=
+ 2.03827260e-11
+ -1.75097034e-13 2.03827260e-11

.Model Wmodel_Trace1677_Auto_2569::MIPI_DSI1_DATA1_P W MODELTYPE=RLGC N=2
+ Lo=
+ 3.30748904e-07
+ 4.21593990e-08 3.30748904e-07
+ Co=
+ 1.03807716e-10
+ -4.52055469e-12 1.03807716e-10
+ Ro=
+ 3.96831067e+00
+ 0.00000000e+00 3.96831067e+00
+ Go=
+ 0.00000000e+00
+ -0.00000000e+00 0.00000000e+00
+ Rs=
+ 1.55902417e-03
+ -0.00000000e+00 1.55902417e-03
+ Gd=
+ 2.03827260e-11
+ -1.75097034e-13 2.03827260e-11

.Model Wmodel_Trace1677_Auto_2573::MIPI_DSI1_DATA1_P W MODELTYPE=RLGC N=2
+ Lo=
+ 3.30748904e-07
+ 4.21593990e-08 3.30748904e-07
+ Co=
+ 1.03807716e-10
+ -4.52055469e-12 1.03807716e-10
+ Ro=
+ 3.96831067e+00
+ 0.00000000e+00 3.96831067e+00
+ Go=
+ 0.00000000e+00
+ -0.00000000e+00 0.00000000e+00
+ Rs=
+ 1.55902417e-03
+ -0.00000000e+00 1.55902417e-03
+ Gd=
+ 2.03827260e-11
+ -1.75097034e-13 2.03827260e-11

.Model Wmodel_Trace1677_Auto_2577::MIPI_DSI1_DATA1_P W MODELTYPE=RLGC N=4
+ Lo=
+ 3.30646008e-07
+ 4.17426541e-08 3.28810121e-07
+ 1.30095172e-08 4.88108361e-08 3.28810121e-07
+ 5.54539989e-09 1.30095172e-08 4.17426540e-08 3.30646008e-07
+ Co=
+ 1.03814813e-10
+ -4.46781108e-12 1.04329552e-10
+ -5.60234413e-13 -5.74687362e-12 1.04329552e-10
+ -2.44795517e-13 -5.60234413e-13 -4.46781108e-12 1.03814813e-10
+ Ro=
+ 3.96831067e+00
+ 0.00000000e+00 3.96831067e+00
+ 0.00000000e+00 0.00000000e+00 3.96831067e+00
+ 0.00000000e+00 0.00000000e+00 0.00000000e+00 3.96831067e+00
+ Go=
+ 0.00000000e+00
+ -0.00000000e+00 0.00000000e+00
+ -0.00000000e+00 -0.00000000e+00 0.00000000e+00
+ -0.00000000e+00 -0.00000000e+00 -0.00000000e+00 0.00000000e+00
+ Rs=
+ 1.55902417e-03
+ -0.00000000e+00 1.55902417e-03
+ -0.00000000e+00 -0.00000000e+00 1.55902417e-03
+ -0.00000000e+00 -0.00000000e+00 -0.00000000e+00 1.55902417e-03
+ Gd=
+ 2.03818111e-11
+ -1.80663921e-13 2.03569591e-11
+ -0.00000000e+00 -3.24268784e-13 2.03569591e-11
+ -0.00000000e+00 -0.00000000e+00 -1.80663921e-13 2.03818111e-11

.Model Wmodel_Trace1677_Auto_2582::MIPI_DSI1_DATA1_P W MODELTYPE=RLGC N=2
+ Lo=
+ 3.30748904e-07
+ 4.21593990e-08 3.30748904e-07
+ Co=
+ 1.03807716e-10
+ -4.52055469e-12 1.03807716e-10
+ Ro=
+ 3.96831067e+00
+ 0.00000000e+00 3.96831067e+00
+ Go=
+ 0.00000000e+00
+ -0.00000000e+00 0.00000000e+00
+ Rs=
+ 1.55902417e-03
+ -0.00000000e+00 1.55902417e-03
+ Gd=
+ 2.03827260e-11
+ -1.75097034e-13 2.03827260e-11

.Model Wmodel_Trace1677_Auto_2598::MIPI_DSI1_DATA1_P W MODELTYPE=RLGC N=2
+ Lo=
+ 3.30748904e-07
+ 4.21593990e-08 3.30748904e-07
+ Co=
+ 1.03807716e-10
+ -4.52055469e-12 1.03807716e-10
+ Ro=
+ 3.96831067e+00
+ 0.00000000e+00 3.96831067e+00
+ Go=
+ 0.00000000e+00
+ -0.00000000e+00 0.00000000e+00
+ Rs=
+ 1.55902417e-03
+ -0.00000000e+00 1.55902417e-03
+ Gd=
+ 2.03827260e-11
+ -1.75097034e-13 2.03827260e-11

.Model Wmodel_Trace1677_Auto_2604::MIPI_DSI1_DATA1_P W MODELTYPE=RLGC N=2
+ Lo=
+ 3.30748904e-07
+ 4.21593990e-08 3.30748904e-07
+ Co=
+ 1.03807716e-10
+ -4.52055469e-12 1.03807716e-10
+ Ro=
+ 3.96831067e+00
+ 0.00000000e+00 3.96831067e+00
+ Go=
+ 0.00000000e+00
+ -0.00000000e+00 0.00000000e+00
+ Rs=
+ 1.55902417e-03
+ -0.00000000e+00 1.55902417e-03
+ Gd=
+ 2.03827260e-11
+ -1.75097034e-13 2.03827260e-11

.Model Wmodel_Trace1677_Auto_2610::MIPI_DSI1_DATA1_P W MODELTYPE=RLGC N=2
+ Lo=
+ 3.30748904e-07
+ 4.21593990e-08 3.30748904e-07
+ Co=
+ 1.03807716e-10
+ -4.52055469e-12 1.03807716e-10
+ Ro=
+ 3.96831067e+00
+ 0.00000000e+00 3.96831067e+00
+ Go=
+ 0.00000000e+00
+ -0.00000000e+00 0.00000000e+00
+ Rs=
+ 1.55902417e-03
+ -0.00000000e+00 1.55902417e-03
+ Gd=
+ 2.03827260e-11
+ -1.75097034e-13 2.03827260e-11

.Model Wmodel_Trace1677_Auto_2619::MIPI_DSI1_DATA1_P W MODELTYPE=RLGC N=1
+ Lo=
+ 3.32029740e-07
+ Co=
+ 1.03489020e-10
+ Ro=
+ 3.96831067e+00
+ Go=
+ 0.00000000e+00
+ Rs=
+ 1.55902417e-03
+ Gd=
+ 2.04067990e-11

.Model Wmodel_Trace1679::MIPI_DSI1_DATA1_P W MODELTYPE=RLGC N=1
+ Lo=
+ 3.32029740e-07
+ Co=
+ 1.03489020e-10
+ Ro=
+ 3.96831067e+00
+ Go=
+ 0.00000000e+00
+ Rs=
+ 1.55902417e-03
+ Gd=
+ 2.04067990e-11

.Model Wmodel_Trace1681_Auto_2512::MIPI_DSI1_DATA1_P W MODELTYPE=RLGC N=1
+ Lo=
+ 3.32029740e-07
+ Co=
+ 1.03489020e-10
+ Ro=
+ 3.96831067e+00
+ Go=
+ 0.00000000e+00
+ Rs=
+ 1.55902417e-03
+ Gd=
+ 2.04067990e-11

.Model Wmodel_Trace1682::MIPI_DSI1_DATA1_P W MODELTYPE=RLGC N=1
+ Lo=
+ 3.32029740e-07
+ Co=
+ 1.03489020e-10
+ Ro=
+ 3.96831067e+00
+ Go=
+ 0.00000000e+00
+ Rs=
+ 1.55902417e-03
+ Gd=
+ 2.04067990e-11

.Model Wmodel_Trace1683::MIPI_DSI1_DATA1_P W MODELTYPE=RLGC N=3
+ Lo=
+ 3.30649701e-07
+ 4.22328852e-08 3.29457335e-07
+ 1.19965486e-08 4.18667264e-08 3.30676023e-07
+ Co=
+ 1.03821519e-10
+ -4.54427787e-12 1.04129519e-10
+ -5.43321299e-13 -4.48209794e-12 1.03812976e-10
+ Ro=
+ 3.96831067e+00
+ 0.00000000e+00 3.96831067e+00
+ 0.00000000e+00 0.00000000e+00 3.96831067e+00
+ Go=
+ 0.00000000e+00
+ -0.00000000e+00 0.00000000e+00
+ -0.00000000e+00 -0.00000000e+00 0.00000000e+00
+ Rs=
+ 1.55902417e-03
+ -0.00000000e+00 1.55902417e-03
+ -0.00000000e+00 -0.00000000e+00 1.55902417e-03
+ Gd=
+ 2.03818074e-11
+ -1.85628713e-13 2.03595487e-11
+ -0.00000000e+00 -1.79449746e-13 2.03820211e-11

.Model Wmodel_Trace1684::MIPI_DSI1_DATA1_P W MODELTYPE=RLGC N=1
+ Lo=
+ 3.32029740e-07
+ Co=
+ 1.03489020e-10
+ Ro=
+ 3.96831067e+00
+ Go=
+ 0.00000000e+00
+ Rs=
+ 1.55902417e-03
+ Gd=
+ 2.04067990e-11

.Model Wmodel_Trace1686::MIPI_DSI1_DATA1_P W MODELTYPE=RLGC N=1
+ Lo=
+ 3.32029740e-07
+ Co=
+ 1.03489020e-10
+ Ro=
+ 3.96831067e+00
+ Go=
+ 0.00000000e+00
+ Rs=
+ 1.55902417e-03
+ Gd=
+ 2.04067990e-11

.Model Wmodel_Trace1686_Auto_2192::MIPI_DSI1_DATA1_P W MODELTYPE=RLGC N=1
+ Lo=
+ 3.32029740e-07
+ Co=
+ 1.03489020e-10
+ Ro=
+ 3.96831067e+00
+ Go=
+ 0.00000000e+00
+ Rs=
+ 1.55902417e-03
+ Gd=
+ 2.04067990e-11

.Model Wmodel_Trace1689::MIPI_DSI1_DATA0_N W MODELTYPE=RLGC N=1
+ Lo=
+ 3.58484574e-07
+ Co=
+ 9.37055974e-11
+ Ro=
+ 4.84133902e+00
+ Go=
+ 0.00000000e+00
+ Rs=
+ 1.72420198e-03
+ Gd=
+ 1.82370500e-11

.Model Wmodel_Trace1691::MIPI_DSI1_DATA0_N W MODELTYPE=RLGC N=1
+ Lo=
+ 3.58484574e-07
+ Co=
+ 9.37055974e-11
+ Ro=
+ 4.84133902e+00
+ Go=
+ 0.00000000e+00
+ Rs=
+ 1.72420198e-03
+ Gd=
+ 1.82370500e-11

.Model Wmodel_Trace1693::MIPI_DSI1_DATA0_N W MODELTYPE=RLGC N=1
+ Lo=
+ 3.32029740e-07
+ Co=
+ 1.03489020e-10
+ Ro=
+ 3.96831067e+00
+ Go=
+ 0.00000000e+00
+ Rs=
+ 1.55902417e-03
+ Gd=
+ 2.04067990e-11

.Model Wmodel_Trace1694_Auto_895::MIPI_DSI1_DATA0_N W MODELTYPE=RLGC N=9
+ Lo=
+ 3.30373726e-07
+ 4.55848056e-08 3.29360847e-07
+ 1.17182868e-08 3.77931520e-08 3.29266338e-07
+ 5.31340846e-09 1.16419079e-08 4.54268327e-08 3.29015035e-07
+ 2.90972862e-09 5.07480406e-09 1.23420617e-08 4.14841385e-08 3.29245629e-07
+ 1.84887306e-09 2.83232223e-09 5.34317970e-09 1.18716864e-08 4.26013684e-08 3.29777656e-07
+ 1.20575445e-09 1.68282214e-09 2.68991236e-09 4.63013512e-09 1.01933567e-08 3.25164316e-08 3.28568528e-07
+ 9.31720467e-10 1.24217667e-09 1.84236684e-09 2.85515273e-09 5.20974477e-09 1.19003271e-08 5.58773926e-08 3.28108437e-07
+ 7.18727168e-10 9.19198363e-10 1.27817845e-09 1.81991030e-09 2.88484613e-09 5.19192274e-09 1.40977252e-08 4.16536648e-08 3.30622302e-07
+ Co=
+ 1.03909868e-10
+ -5.13368808e-12 1.04144729e-10
+ -5.18351148e-13 -3.82631492e-12 1.04154939e-10
+ -2.22935002e-13 -5.04282483e-13 -5.12493160e-12 1.04233025e-10
+ -1.24416615e-13 -2.13913168e-13 -5.28731047e-13 -4.43730012e-12 1.04156917e-10
+ -8.05106224e-14 -1.20360060e-13 -2.22289148e-13 -5.15421377e-13 -4.62363398e-12 1.03995531e-10
+ -5.25239285e-14 -7.15064791e-14 -1.12736718e-13 -1.95717849e-13 -4.51042781e-13 -3.02668474e-12 1.04445331e-10
+ -3.94135763e-14 -5.09196869e-14 -7.41339337e-14 -1.14168689e-13 -2.07547805e-13 -5.05683308e-13 -7.14377984e-12 1.04600934e-10
+ -3.29654187e-14 -4.07614772e-14 -5.57330216e-14 -7.88174847e-14 -1.24453324e-13 -2.29213102e-13 -5.91740839e-13 -4.45760198e-12 1.03816492e-10
+ Ro=
+ 3.96831067e+00
+ 0.00000000e+00 3.96831067e+00
+ 0.00000000e+00 0.00000000e+00 3.96831067e+00
+ 0.00000000e+00 0.00000000e+00 0.00000000e+00 3.96831067e+00
+ 0.00000000e+00 0.00000000e+00 0.00000000e+00 0.00000000e+00 3.96831067e+00
+ 0.00000000e+00 0.00000000e+00 0.00000000e+00 0.00000000e+00 0.00000000e+00 3.96831067e+00
+ 0.00000000e+00 0.00000000e+00 0.00000000e+00 0.00000000e+00 0.00000000e+00 0.00000000e+00 3.96831067e+00
+ 0.00000000e+00 0.00000000e+00 0.00000000e+00 0.00000000e+00 0.00000000e+00 0.00000000e+00 0.00000000e+00 3.96831067e+00
+ 0.00000000e+00 0.00000000e+00 0.00000000e+00 0.00000000e+00 0.00000000e+00 0.00000000e+00 0.00000000e+00 0.00000000e+00 3.96831067e+00
+ Go=
+ 0.00000000e+00
+ -0.00000000e+00 0.00000000e+00
+ -0.00000000e+00 -0.00000000e+00 0.00000000e+00
+ -0.00000000e+00 -0.00000000e+00 -0.00000000e+00 0.00000000e+00
+ -0.00000000e+00 -0.00000000e+00 -0.00000000e+00 -0.00000000e+00 0.00000000e+00
+ -0.00000000e+00 -0.00000000e+00 -0.00000000e+00 -0.00000000e+00 -0.00000000e+00 0.00000000e+00
+ -0.00000000e+00 -0.00000000e+00 -0.00000000e+00 -0.00000000e+00 -0.00000000e+00 -0.00000000e+00 0.00000000e+00
+ -0.00000000e+00 -0.00000000e+00 -0.00000000e+00 -0.00000000e+00 -0.00000000e+00 -0.00000000e+00 -0.00000000e+00 0.00000000e+00
+ -0.00000000e+00 -0.00000000e+00 -0.00000000e+00 -0.00000000e+00 -0.00000000e+00 -0.00000000e+00 -0.00000000e+00 -0.00000000e+00 0.00000000e+00
+ Rs=
+ 1.55902417e-03
+ -0.00000000e+00 1.55902417e-03
+ -0.00000000e+00 -0.00000000e+00 1.55902417e-03
+ -0.00000000e+00 -0.00000000e+00 -0.00000000e+00 1.55902417e-03
+ -0.00000000e+00 -0.00000000e+00 -0.00000000e+00 -0.00000000e+00 1.55902417e-03
+ -0.00000000e+00 -0.00000000e+00 -0.00000000e+00 -0.00000000e+00 -0.00000000e+00 1.55902417e-03
+ -0.00000000e+00 -0.00000000e+00 -0.00000000e+00 -0.00000000e+00 -0.00000000e+00 -0.00000000e+00 1.55902417e-03
+ -0.00000000e+00 -0.00000000e+00 -0.00000000e+00 -0.00000000e+00 -0.00000000e+00 -0.00000000e+00 -0.00000000e+00 1.55902417e-03
+ -0.00000000e+00 -0.00000000e+00 -0.00000000e+00 -0.00000000e+00 -0.00000000e+00 -0.00000000e+00 -0.00000000e+00 -0.00000000e+00 1.55902417e-03
+ Gd=
+ 2.03800643e-11
+ -2.47026652e-13 2.03597451e-11
+ -0.00000000e+00 -1.26107245e-13 2.03590219e-11
+ -0.00000000e+00 -0.00000000e+00 -2.54875070e-13 2.03565478e-11
+ -0.00000000e+00 -0.00000000e+00 -0.00000000e+00 -1.85167656e-13 2.03577117e-11
+ -0.00000000e+00 -0.00000000e+00 -0.00000000e+00 -0.00000000e+00 -2.00409454e-13 2.03643034e-11
+ -0.00000000e+00 -0.00000000e+00 -0.00000000e+00 -0.00000000e+00 -0.00000000e+00 -5.98535294e-14 2.03660071e-11
+ -0.00000000e+00 -0.00000000e+00 -0.00000000e+00 -0.00000000e+00 -0.00000000e+00 -0.00000000e+00 -4.88564875e-13 2.03601564e-11
+ -0.00000000e+00 -0.00000000e+00 -0.00000000e+00 -0.00000000e+00 -0.00000000e+00 -0.00000000e+00 -0.00000000e+00 -1.81955825e-13 2.03816729e-11

.Model Wmodel_Trace1695::MIPI_DSI1_DATA0_N W MODELTYPE=RLGC N=5
+ Lo=
+ 3.29324766e-07
+ 5.60790908e-08 3.28082347e-07
+ 1.39868411e-08 4.11703854e-08 3.27992431e-07
+ 6.53820056e-09 1.38886019e-08 5.57389557e-08 3.28076413e-07
+ 3.41105589e-09 5.74399707e-09 1.40577018e-08 4.16433246e-08 3.30620770e-07
+ Co=
+ 1.04292615e-10
+ -7.16823539e-12 1.04601781e-10
+ -5.76600469e-13 -4.39666804e-12 1.04606900e-10
+ -2.51748131e-13 -5.61804907e-13 -7.12829626e-12 1.04602012e-10
+ -1.44958855e-13 -2.41499169e-13 -5.86090314e-13 -4.45701542e-12 1.03816441e-10
+ Ro=
+ 3.96831067e+00
+ 0.00000000e+00 3.96831067e+00
+ 0.00000000e+00 0.00000000e+00 3.96831067e+00
+ 0.00000000e+00 0.00000000e+00 0.00000000e+00 3.96831067e+00
+ 0.00000000e+00 0.00000000e+00 0.00000000e+00 0.00000000e+00 3.96831067e+00
+ Go=
+ 0.00000000e+00
+ -0.00000000e+00 0.00000000e+00
+ -0.00000000e+00 -0.00000000e+00 0.00000000e+00
+ -0.00000000e+00 -0.00000000e+00 -0.00000000e+00 0.00000000e+00
+ -0.00000000e+00 -0.00000000e+00 -0.00000000e+00 -0.00000000e+00 0.00000000e+00
+ Rs=
+ 1.55902417e-03
+ -0.00000000e+00 1.55902417e-03
+ -0.00000000e+00 -0.00000000e+00 1.55902417e-03
+ -0.00000000e+00 -0.00000000e+00 -0.00000000e+00 1.55902417e-03
+ -0.00000000e+00 -0.00000000e+00 -0.00000000e+00 -0.00000000e+00 1.55902417e-03
+ Gd=
+ 2.03823244e-11
+ -4.85385610e-13 2.03601117e-11
+ -0.00000000e+00 -1.87398655e-13 2.03594907e-11
+ -0.00000000e+00 -0.00000000e+00 -4.89725950e-13 2.03600581e-11
+ -0.00000000e+00 -0.00000000e+00 -0.00000000e+00 -1.81941906e-13 2.03816859e-11

.Model Wmodel_Trace1695_Auto_1756::MIPI_DSI1_DATA0_N W MODELTYPE=RLGC N=1
+ Lo=
+ 3.32029740e-07
+ Co=
+ 1.03489020e-10
+ Ro=
+ 3.96831067e+00
+ Go=
+ 0.00000000e+00
+ Rs=
+ 1.55902417e-03
+ Gd=
+ 2.04067990e-11

.Model Wmodel_Trace1697::MIPI_DSI1_DATA0_N W MODELTYPE=RLGC N=1
+ Lo=
+ 3.32029740e-07
+ Co=
+ 1.03489020e-10
+ Ro=
+ 3.96831067e+00
+ Go=
+ 0.00000000e+00
+ Rs=
+ 1.55902417e-03
+ Gd=
+ 2.04067990e-11

.Model Wmodel_Trace1699::MIPI_DSI1_DATA0_N W MODELTYPE=RLGC N=1
+ Lo=
+ 3.32029740e-07
+ Co=
+ 1.03489020e-10
+ Ro=
+ 3.96831067e+00
+ Go=
+ 0.00000000e+00
+ Rs=
+ 1.55902417e-03
+ Gd=
+ 2.04067990e-11

.Model Wmodel_Trace1701::MIPI_DSI1_DATA0_N W MODELTYPE=RLGC N=1
+ Lo=
+ 3.32029740e-07
+ Co=
+ 1.03489020e-10
+ Ro=
+ 3.96831067e+00
+ Go=
+ 0.00000000e+00
+ Rs=
+ 1.55902417e-03
+ Gd=
+ 2.04067990e-11

.Model Wmodel_Trace1701_Auto_69::MIPI_DSI1_DATA0_N W MODELTYPE=RLGC N=3
+ Lo=
+ 3.30678013e-07
+ 4.19117051e-08 3.29573316e-07
+ 1.17146736e-08 4.05620182e-08 3.30772389e-07
+ Co=
+ 1.03813365e-10
+ -4.48899799e-12 1.04092330e-10
+ -5.34297923e-13 -4.26282479e-12 1.03783203e-10
+ Ro=
+ 3.96831067e+00
+ 0.00000000e+00 3.96831067e+00
+ 0.00000000e+00 0.00000000e+00 3.96831067e+00
+ Go=
+ 0.00000000e+00
+ -0.00000000e+00 0.00000000e+00
+ -0.00000000e+00 -0.00000000e+00 0.00000000e+00
+ Rs=
+ 1.55902417e-03
+ -0.00000000e+00 1.55902417e-03
+ -0.00000000e+00 -0.00000000e+00 1.55902417e-03
+ Gd=
+ 2.03820241e-11
+ -1.79650524e-13 2.03605183e-11
+ -0.00000000e+00 -1.57580416e-13 2.03828756e-11

.Model Wmodel_Trace1702::MIPI_DSI1_DATA0_N W MODELTYPE=RLGC N=1
+ Lo=
+ 3.32029740e-07
+ Co=
+ 1.03489020e-10
+ Ro=
+ 3.96831067e+00
+ Go=
+ 0.00000000e+00
+ Rs=
+ 1.55902417e-03
+ Gd=
+ 2.04067990e-11

.Model Wmodel_Trace1710::MIPI_DSI1_DATA0_N W MODELTYPE=RLGC N=1
+ Lo=
+ 3.32029740e-07
+ Co=
+ 1.03489020e-10
+ Ro=
+ 3.96831067e+00
+ Go=
+ 0.00000000e+00
+ Rs=
+ 1.55902417e-03
+ Gd=
+ 2.04067990e-11

.Model Wmodel_Trace1710_Auto_64::MIPI_DSI1_DATA0_N W MODELTYPE=RLGC N=2
+ Lo=
+ 3.31090758e-07
+ 3.69663702e-08 3.31090758e-07
+ Co=
+ 1.03702334e-10
+ -3.67878977e-12 1.03702334e-10
+ Ro=
+ 3.96831067e+00
+ 0.00000000e+00 3.96831067e+00
+ Go=
+ 0.00000000e+00
+ -0.00000000e+00 0.00000000e+00
+ Rs=
+ 1.55902417e-03
+ -0.00000000e+00 1.55902417e-03
+ Gd=
+ 2.03864930e-11
+ -9.56893964e-14 2.03864930e-11

.Model Wmodel_Trace1710_Auto_65::MIPI_DSI1_DATA0_N W MODELTYPE=RLGC N=1
+ Lo=
+ 3.32029740e-07
+ Co=
+ 1.03489020e-10
+ Ro=
+ 3.96831067e+00
+ Go=
+ 0.00000000e+00
+ Rs=
+ 1.55902417e-03
+ Gd=
+ 2.04067990e-11

.Model Wmodel_Trace1714::MIPI_DSI1_DATA0_N W MODELTYPE=RLGC N=1
+ Lo=
+ 3.32029740e-07
+ Co=
+ 1.03489020e-10
+ Ro=
+ 3.96831067e+00
+ Go=
+ 0.00000000e+00
+ Rs=
+ 1.55902417e-03
+ Gd=
+ 2.04067990e-11

.Model Wmodel_Trace1718_Auto_60::MIPI_DSI1_DATA0_N W MODELTYPE=RLGC N=4
+ Lo=
+ 3.30666109e-07
+ 4.18833957e-08 3.29503290e-07
+ 1.16059104e-08 4.02731099e-08 3.29438407e-07
+ 5.19755260e-09 1.17593313e-08 4.28024227e-08 3.30596587e-07
+ Co=
+ 1.03814316e-10
+ -4.48683795e-12 1.04097255e-10
+ -5.18195170e-13 -4.22533300e-12 1.04118995e-10
+ -2.30131368e-13 -5.23456189e-13 -4.64401180e-12 1.03836453e-10
+ Ro=
+ 3.96831067e+00
+ 0.00000000e+00 3.96831067e+00
+ 0.00000000e+00 0.00000000e+00 3.96831067e+00
+ 0.00000000e+00 0.00000000e+00 0.00000000e+00 3.96831067e+00
+ Go=
+ 0.00000000e+00
+ -0.00000000e+00 0.00000000e+00
+ -0.00000000e+00 -0.00000000e+00 0.00000000e+00
+ -0.00000000e+00 -0.00000000e+00 -0.00000000e+00 0.00000000e+00
+ Rs=
+ 1.55902417e-03
+ -0.00000000e+00 1.55902417e-03
+ -0.00000000e+00 -0.00000000e+00 1.55902417e-03
+ -0.00000000e+00 -0.00000000e+00 -0.00000000e+00 1.55902417e-03
+ Gd=
+ 2.03818956e-11
+ -1.79934483e-13 2.03598884e-11
+ -0.00000000e+00 -1.61763358e-13 2.03594091e-11
+ -0.00000000e+00 -0.00000000e+00 -1.95918096e-13 2.03813611e-11

.Model Wmodel_Trace1719::MIPI_DSI1_DATA0_N W MODELTYPE=RLGC N=1
+ Lo=
+ 3.32029740e-07
+ Co=
+ 1.03489020e-10
+ Ro=
+ 3.96831067e+00
+ Go=
+ 0.00000000e+00
+ Rs=
+ 1.55902417e-03
+ Gd=
+ 2.04067990e-11

.Model Wmodel_Trace1724::MIPI_DSI1_DATA0_N W MODELTYPE=RLGC N=2
+ Lo=
+ 3.30798850e-07
+ 4.14572798e-08 3.30798850e-07
+ Co=
+ 1.03791658e-10
+ -4.40234673e-12 1.03791658e-10
+ Ro=
+ 3.96831067e+00
+ 0.00000000e+00 3.96831067e+00
+ Go=
+ 0.00000000e+00
+ -0.00000000e+00 0.00000000e+00
+ Rs=
+ 1.55902417e-03
+ -0.00000000e+00 1.55902417e-03
+ Gd=
+ 2.03831601e-11
+ -1.63329939e-13 2.03831601e-11

.Model Wmodel_Trace1725::MIPI_DSI1_DATA0_N W MODELTYPE=RLGC N=2
+ Lo=
+ 3.30798400e-07
+ 4.14636751e-08 3.30798400e-07
+ Co=
+ 1.03791802e-10
+ -4.40341733e-12 1.03791802e-10
+ Ro=
+ 3.96831067e+00
+ 0.00000000e+00 3.96831067e+00
+ Go=
+ 0.00000000e+00
+ -0.00000000e+00 0.00000000e+00
+ Rs=
+ 1.55902417e-03
+ -0.00000000e+00 1.55902417e-03
+ Gd=
+ 2.03831560e-11
+ -1.63435690e-13 2.03831560e-11

.Model Wmodel_Trace1726::MIPI_DSI1_DATA0_N W MODELTYPE=RLGC N=1
+ Lo=
+ 3.32029740e-07
+ Co=
+ 1.03489020e-10
+ Ro=
+ 3.96831067e+00
+ Go=
+ 0.00000000e+00
+ Rs=
+ 1.55902417e-03
+ Gd=
+ 2.04067990e-11

.Model Wmodel_Trace1727::MIPI_DSI1_DATA0_N W MODELTYPE=RLGC N=1
+ Lo=
+ 3.32029740e-07
+ Co=
+ 1.03489020e-10
+ Ro=
+ 3.96831067e+00
+ Go=
+ 0.00000000e+00
+ Rs=
+ 1.55902417e-03
+ Gd=
+ 2.04067990e-11

.Model Wmodel_Trace1731::MIPI_DSI1_DATA0_N W MODELTYPE=RLGC N=1
+ Lo=
+ 3.32029740e-07
+ Co=
+ 1.03489020e-10
+ Ro=
+ 3.96831067e+00
+ Go=
+ 0.00000000e+00
+ Rs=
+ 1.55902417e-03
+ Gd=
+ 2.04067990e-11

.Model Wmodel_Trace1733_Auto_379::MIPI_DSI1_DATA0_N W MODELTYPE=RLGC N=1
+ Lo=
+ 3.32029740e-07
+ Co=
+ 1.03489020e-10
+ Ro=
+ 3.96831067e+00
+ Go=
+ 0.00000000e+00
+ Rs=
+ 1.55902417e-03
+ Gd=
+ 2.04067990e-11

.Model Wmodel_Trace1735::MIPI_DSI1_DATA0_N W MODELTYPE=RLGC N=1
+ Lo=
+ 3.32029740e-07
+ Co=
+ 1.03489020e-10
+ Ro=
+ 3.96831067e+00
+ Go=
+ 0.00000000e+00
+ Rs=
+ 1.55902417e-03
+ Gd=
+ 2.04067990e-11

.Model Wmodel_Trace1742::MIPI_DSI1_DATA0_N W MODELTYPE=RLGC N=1
+ Lo=
+ 3.32029740e-07
+ Co=
+ 1.03489020e-10
+ Ro=
+ 3.96831067e+00
+ Go=
+ 0.00000000e+00
+ Rs=
+ 1.55902417e-03
+ Gd=
+ 2.04067990e-11

.Model Wmodel_Trace1743::MIPI_DSI1_DATA0_N W MODELTYPE=RLGC N=1
+ Lo=
+ 3.32029740e-07
+ Co=
+ 1.03489020e-10
+ Ro=
+ 3.96831067e+00
+ Go=
+ 0.00000000e+00
+ Rs=
+ 1.55902417e-03
+ Gd=
+ 2.04067990e-11

.Model Wmodel_Trace1743_Auto_2138::MIPI_DSI1_DATA0_N W MODELTYPE=RLGC N=1
+ Lo=
+ 3.32029740e-07
+ Co=
+ 1.03489020e-10
+ Ro=
+ 3.96831067e+00
+ Go=
+ 0.00000000e+00
+ Rs=
+ 1.55902417e-03
+ Gd=
+ 2.04067990e-11

.Model Wmodel_Trace1745::MIPI_DSI1_DATA0_N W MODELTYPE=RLGC N=1
+ Lo=
+ 3.32029740e-07
+ Co=
+ 1.03489020e-10
+ Ro=
+ 3.96831067e+00
+ Go=
+ 0.00000000e+00
+ Rs=
+ 1.55902417e-03
+ Gd=
+ 2.04067990e-11

.Model Wmodel_Trace1747::MIPI_DSI1_DATA0_N W MODELTYPE=RLGC N=1
+ Lo=
+ 3.32029740e-07
+ Co=
+ 1.03489020e-10
+ Ro=
+ 3.96831067e+00
+ Go=
+ 0.00000000e+00
+ Rs=
+ 1.55902417e-03
+ Gd=
+ 2.04067990e-11

.Model Wmodel_Trace1751::MIPI_DSI1_DATA0_N W MODELTYPE=RLGC N=1
+ Lo=
+ 3.32029740e-07
+ Co=
+ 1.03489020e-10
+ Ro=
+ 3.96831067e+00
+ Go=
+ 0.00000000e+00
+ Rs=
+ 1.55902417e-03
+ Gd=
+ 2.04067990e-11

.Model Wmodel_Trace1753::MIPI_DSI1_DATA0_N W MODELTYPE=RLGC N=1
+ Lo=
+ 3.32029740e-07
+ Co=
+ 1.03489020e-10
+ Ro=
+ 3.96831067e+00
+ Go=
+ 0.00000000e+00
+ Rs=
+ 1.55902417e-03
+ Gd=
+ 2.04067990e-11

.Model Wmodel_Trace1753_Auto_2166::MIPI_DSI1_DATA0_N W MODELTYPE=RLGC N=1
+ Lo=
+ 3.32029740e-07
+ Co=
+ 1.03489020e-10
+ Ro=
+ 3.96831067e+00
+ Go=
+ 0.00000000e+00
+ Rs=
+ 1.55902417e-03
+ Gd=
+ 2.04067990e-11

.Model Wmodel_Trace1755::MIPI_DSI1_DATA0_N W MODELTYPE=RLGC N=1
+ Lo=
+ 3.32029740e-07
+ Co=
+ 1.03489020e-10
+ Ro=
+ 3.96831067e+00
+ Go=
+ 0.00000000e+00
+ Rs=
+ 1.55902417e-03
+ Gd=
+ 2.04067990e-11

.Model Wmodel_Trace1756::MIPI_DSI1_DATA0_N W MODELTYPE=RLGC N=1
+ Lo=
+ 8.24350330e-07
+ Co=
+ 3.67394016e-11
+ Ro=
+ 3.96831067e+00
+ Go=
+ 0.00000000e+00
+ Rs=
+ 1.02517469e-03
+ Gd=
+ 6.50321060e-12

.Model Wmodel_Trace1761::MIPI_DSI1_DATA0_N W MODELTYPE=RLGC N=1
+ Lo=
+ 3.32029740e-07
+ Co=
+ 1.03489020e-10
+ Ro=
+ 3.96831067e+00
+ Go=
+ 0.00000000e+00
+ Rs=
+ 1.55902417e-03
+ Gd=
+ 2.04067990e-11

.Model Wmodel_Trace1762#BP0::MIPI_DSI1_DATA0_N W MODELTYPE=RLGC N=1
+ Lo=
+ 3.32029740e-07
+ Co=
+ 1.03489020e-10
+ Ro=
+ 3.96831067e+00
+ Go=
+ 0.00000000e+00
+ Rs=
+ 1.55902417e-03
+ Gd=
+ 2.04067990e-11

.Model Wmodel_Trace1762::MIPI_DSI1_DATA0_N W MODELTYPE=RLGC N=1
+ Lo=
+ 8.24350330e-07
+ Co=
+ 3.67394016e-11
+ Ro=
+ 3.96831067e+00
+ Go=
+ 0.00000000e+00
+ Rs=
+ 1.02517469e-03
+ Gd=
+ 6.50321060e-12

.Model Wmodel_Trace1764::MIPI_DSI1_DATA0_N W MODELTYPE=RLGC N=1
+ Lo=
+ 3.32029740e-07
+ Co=
+ 1.03489020e-10
+ Ro=
+ 3.96831067e+00
+ Go=
+ 0.00000000e+00
+ Rs=
+ 1.55902417e-03
+ Gd=
+ 2.04067990e-11

.Model Wmodel_Trace1764_Auto_2163::MIPI_DSI1_DATA0_N W MODELTYPE=RLGC N=4
+ Lo=
+ 3.30627493e-07
+ 4.22908879e-08 3.29307047e-07
+ 1.20651161e-08 4.25176377e-08 3.29306647e-07
+ 5.30745314e-09 1.20661150e-08 4.22965830e-08 3.30627061e-07
+ Co=
+ 1.03825008e-10
+ -4.55749349e-12 1.04159465e-10
+ -5.32788704e-13 -4.60629983e-12 1.04159599e-10
+ -2.34583083e-13 -5.32822589e-13 -4.55846746e-12 1.03825145e-10
+ Ro=
+ 3.96831067e+00
+ 0.00000000e+00 3.96831067e+00
+ 0.00000000e+00 0.00000000e+00 3.96831067e+00
+ 0.00000000e+00 0.00000000e+00 0.00000000e+00 3.96831067e+00
+ Go=
+ 0.00000000e+00
+ -0.00000000e+00 0.00000000e+00
+ -0.00000000e+00 -0.00000000e+00 0.00000000e+00
+ -0.00000000e+00 -0.00000000e+00 -0.00000000e+00 0.00000000e+00
+ Rs=
+ 1.55902417e-03
+ -0.00000000e+00 1.55902417e-03
+ -0.00000000e+00 -0.00000000e+00 1.55902417e-03
+ -0.00000000e+00 -0.00000000e+00 -0.00000000e+00 1.55902417e-03
+ Gd=
+ 2.03816056e-11
+ -1.87776818e-13 2.03583440e-11
+ -0.00000000e+00 -2.00127630e-13 2.03583410e-11
+ -0.00000000e+00 -0.00000000e+00 -1.87875863e-13 2.03816023e-11

.Model Wmodel_Trace1764_Auto_2164::MIPI_DSI1_DATA0_N W MODELTYPE=RLGC N=1
+ Lo=
+ 3.32029740e-07
+ Co=
+ 1.03489020e-10
+ Ro=
+ 3.96831067e+00
+ Go=
+ 0.00000000e+00
+ Rs=
+ 1.55902417e-03
+ Gd=
+ 2.04067990e-11

.Model Wmodel_Trace1773::MIPI_DSI1_DATA0_N W MODELTYPE=RLGC N=1
+ Lo=
+ 3.32029740e-07
+ Co=
+ 1.03489020e-10
+ Ro=
+ 3.96831067e+00
+ Go=
+ 0.00000000e+00
+ Rs=
+ 1.55902417e-03
+ Gd=
+ 2.04067990e-11

.Model Wmodel_Trace1775::MIPI_DSI1_DATA0_N W MODELTYPE=RLGC N=1
+ Lo=
+ 3.32029740e-07
+ Co=
+ 1.03489020e-10
+ Ro=
+ 3.96831067e+00
+ Go=
+ 0.00000000e+00
+ Rs=
+ 1.55902417e-03
+ Gd=
+ 2.04067990e-11

.Model Wmodel_Trace1775_Auto_2145::MIPI_DSI1_DATA0_N W MODELTYPE=RLGC N=1
+ Lo=
+ 3.32029740e-07
+ Co=
+ 1.03489020e-10
+ Ro=
+ 3.96831067e+00
+ Go=
+ 0.00000000e+00
+ Rs=
+ 1.55902417e-03
+ Gd=
+ 2.04067990e-11

.Model Wmodel_Trace1777::MIPI_DSI1_DATA0_N W MODELTYPE=RLGC N=1
+ Lo=
+ 3.32029740e-07
+ Co=
+ 1.03489020e-10
+ Ro=
+ 3.96831067e+00
+ Go=
+ 0.00000000e+00
+ Rs=
+ 1.55902417e-03
+ Gd=
+ 2.04067990e-11

.Model Wmodel_Trace1786::MIPI_DSI1_DATA0_N W MODELTYPE=RLGC N=1
+ Lo=
+ 3.32029740e-07
+ Co=
+ 1.03489020e-10
+ Ro=
+ 3.96831067e+00
+ Go=
+ 0.00000000e+00
+ Rs=
+ 1.55902417e-03
+ Gd=
+ 2.04067990e-11

.Model Wmodel_Trace1786_Auto_2143::MIPI_DSI1_DATA0_N W MODELTYPE=RLGC N=1
+ Lo=
+ 3.32029740e-07
+ Co=
+ 1.03489020e-10
+ Ro=
+ 3.96831067e+00
+ Go=
+ 0.00000000e+00
+ Rs=
+ 1.55902417e-03
+ Gd=
+ 2.04067990e-11

.Model Wmodel_Trace1786_Auto_2156::MIPI_DSI1_DATA0_N W MODELTYPE=RLGC N=8
+ Lo=
+ 3.30621759e-07
+ 4.23011126e-08 3.29295353e-07
+ 1.20512568e-08 4.24768056e-08 3.29260823e-07
+ 5.27135098e-09 1.20003065e-08 4.21611339e-08 3.30197819e-07
+ 2.46078739e-09 4.17149901e-09 8.59825414e-09 2.49124967e-08 3.30235357e-07
+ 1.60706487e-09 2.42824323e-09 4.14045882e-09 8.55190160e-09 4.17133122e-08 3.29388898e-07
+ 1.13211875e-09 1.58527377e-09 2.40852652e-09 4.11192941e-09 1.17127937e-08 4.12480472e-08 3.29424159e-07
+ 8.50530526e-10 1.12964493e-09 1.59250023e-09 2.42676214e-09 5.16440534e-09 1.17611697e-08 4.18415069e-08 3.30661150e-07
+ Co=
+ 1.03825843e-10
+ -4.55981907e-12 1.04160444e-10
+ -5.31542617e-13 -4.60130286e-12 1.04163043e-10
+ -2.29843641e-13 -5.25119365e-13 -4.54272178e-12 1.03897826e-10
+ -1.12156206e-13 -1.84836504e-13 -3.96894446e-13 -2.02301441e-12 1.03886676e-10
+ -7.05783115e-14 -1.02468049e-13 -1.75243623e-13 -3.95719891e-13 -4.46559143e-12 1.04122587e-10
+ -5.00180792e-14 -6.71001767e-14 -1.01793225e-13 -1.83009304e-13 -5.16454579e-13 -4.39056283e-12 1.04119709e-10
+ -3.92573848e-14 -4.97799958e-14 -6.98438682e-14 -1.10751933e-13 -2.26214000e-13 -5.22769842e-13 -4.48072147e-12 1.03814313e-10
+ Ro=
+ 3.96831067e+00
+ 0.00000000e+00 3.96831067e+00
+ 0.00000000e+00 0.00000000e+00 3.96831067e+00
+ 0.00000000e+00 0.00000000e+00 0.00000000e+00 3.96831067e+00
+ 0.00000000e+00 0.00000000e+00 0.00000000e+00 0.00000000e+00 3.96831067e+00
+ 0.00000000e+00 0.00000000e+00 0.00000000e+00 0.00000000e+00 0.00000000e+00 3.96831067e+00
+ 0.00000000e+00 0.00000000e+00 0.00000000e+00 0.00000000e+00 0.00000000e+00 0.00000000e+00 3.96831067e+00
+ 0.00000000e+00 0.00000000e+00 0.00000000e+00 0.00000000e+00 0.00000000e+00 0.00000000e+00 0.00000000e+00 3.96831067e+00
+ Go=
+ 0.00000000e+00
+ -0.00000000e+00 0.00000000e+00
+ -0.00000000e+00 -0.00000000e+00 0.00000000e+00
+ -0.00000000e+00 -0.00000000e+00 -0.00000000e+00 0.00000000e+00
+ -0.00000000e+00 -0.00000000e+00 -0.00000000e+00 -0.00000000e+00 0.00000000e+00
+ -0.00000000e+00 -0.00000000e+00 -0.00000000e+00 -0.00000000e+00 -0.00000000e+00 0.00000000e+00
+ -0.00000000e+00 -0.00000000e+00 -0.00000000e+00 -0.00000000e+00 -0.00000000e+00 -0.00000000e+00 0.00000000e+00
+ -0.00000000e+00 -0.00000000e+00 -0.00000000e+00 -0.00000000e+00 -0.00000000e+00 -0.00000000e+00 -0.00000000e+00 0.00000000e+00
+ Rs=
+ 1.55902417e-03
+ -0.00000000e+00 1.55902417e-03
+ -0.00000000e+00 -0.00000000e+00 1.55902417e-03
+ -0.00000000e+00 -0.00000000e+00 -0.00000000e+00 1.55902417e-03
+ -0.00000000e+00 -0.00000000e+00 -0.00000000e+00 -0.00000000e+00 1.55902417e-03
+ -0.00000000e+00 -0.00000000e+00 -0.00000000e+00 -0.00000000e+00 -0.00000000e+00 1.55902417e-03
+ -0.00000000e+00 -0.00000000e+00 -0.00000000e+00 -0.00000000e+00 -0.00000000e+00 -0.00000000e+00 1.55902417e-03
+ -0.00000000e+00 -0.00000000e+00 -0.00000000e+00 -0.00000000e+00 -0.00000000e+00 -0.00000000e+00 -0.00000000e+00 1.55902417e-03
+ Gd=
+ 2.03815344e-11
+ -1.88165106e-13 2.03582072e-11
+ -0.00000000e+00 -2.00086734e-13 2.03578129e-11
+ -0.00000000e+00 -0.00000000e+00 -1.90114533e-13 2.03715095e-11
+ -0.00000000e+00 -0.00000000e+00 -0.00000000e+00 -0.00000000e+00 2.03717900e-11
+ -0.00000000e+00 -0.00000000e+00 -0.00000000e+00 -0.00000000e+00 -1.81919712e-13 2.03587594e-11
+ -0.00000000e+00 -0.00000000e+00 -0.00000000e+00 -0.00000000e+00 -0.00000000e+00 -1.78366028e-13 2.03591613e-11
+ -0.00000000e+00 -0.00000000e+00 -0.00000000e+00 -0.00000000e+00 -0.00000000e+00 -0.00000000e+00 -1.79767612e-13 2.03818372e-11

.Model Wmodel_Trace1792::MIPI_DSI1_DATA0_N W MODELTYPE=RLGC N=1
+ Lo=
+ 3.32029740e-07
+ Co=
+ 1.03489020e-10
+ Ro=
+ 3.96831067e+00
+ Go=
+ 0.00000000e+00
+ Rs=
+ 1.55902417e-03
+ Gd=
+ 2.04067990e-11

.Model Wmodel_Trace1793::MIPI_DSI1_DATA0_N W MODELTYPE=RLGC N=1
+ Lo=
+ 3.32029740e-07
+ Co=
+ 1.03489020e-10
+ Ro=
+ 3.96831067e+00
+ Go=
+ 0.00000000e+00
+ Rs=
+ 1.55902417e-03
+ Gd=
+ 2.04067990e-11

.Model Wmodel_Trace1793_Auto_2168::MIPI_DSI1_DATA0_N W MODELTYPE=RLGC N=1
+ Lo=
+ 3.32029740e-07
+ Co=
+ 1.03489020e-10
+ Ro=
+ 3.96831067e+00
+ Go=
+ 0.00000000e+00
+ Rs=
+ 1.55902417e-03
+ Gd=
+ 2.04067990e-11

.Model Wmodel_Trace1795::MIPI_DSI1_DATA0_N W MODELTYPE=RLGC N=1
+ Lo=
+ 3.32029740e-07
+ Co=
+ 1.03489020e-10
+ Ro=
+ 3.96831067e+00
+ Go=
+ 0.00000000e+00
+ Rs=
+ 1.55902417e-03
+ Gd=
+ 2.04067990e-11

.Model Wmodel_Trace1798::MIPI_DSI1_DATA0_N W MODELTYPE=RLGC N=1
+ Lo=
+ 3.32029740e-07
+ Co=
+ 1.03489020e-10
+ Ro=
+ 3.96831067e+00
+ Go=
+ 0.00000000e+00
+ Rs=
+ 1.55902417e-03
+ Gd=
+ 2.04067990e-11

.Model Wmodel_Trace1801::MIPI_DSI1_DATA0_N W MODELTYPE=RLGC N=1
+ Lo=
+ 3.32029740e-07
+ Co=
+ 1.03489020e-10
+ Ro=
+ 3.96831067e+00
+ Go=
+ 0.00000000e+00
+ Rs=
+ 1.55902417e-03
+ Gd=
+ 2.04067990e-11

.Model Wmodel_Trace1806::MIPI_DSI1_DATA0_N W MODELTYPE=RLGC N=1
+ Lo=
+ 3.32029740e-07
+ Co=
+ 1.03489020e-10
+ Ro=
+ 3.96831067e+00
+ Go=
+ 0.00000000e+00
+ Rs=
+ 1.55902417e-03
+ Gd=
+ 2.04067990e-11

.Model Wmodel_Trace1806_Auto_2178::MIPI_DSI1_DATA0_N W MODELTYPE=RLGC N=2
+ Lo=
+ 3.30748548e-07
+ 4.21643405e-08 3.30748548e-07
+ Co=
+ 1.03807831e-10
+ -4.52139143e-12 1.03807831e-10
+ Ro=
+ 3.96831067e+00
+ 0.00000000e+00 3.96831067e+00
+ Go=
+ 0.00000000e+00
+ -0.00000000e+00 0.00000000e+00
+ Rs=
+ 1.55902417e-03
+ -0.00000000e+00 1.55902417e-03
+ Gd=
+ 2.03827231e-11
+ -1.75180973e-13 2.03827231e-11

.Model Wmodel_Trace1808::MIPI_DSI1_DATA0_N W MODELTYPE=RLGC N=1
+ Lo=
+ 3.32029740e-07
+ Co=
+ 1.03489020e-10
+ Ro=
+ 3.96831067e+00
+ Go=
+ 0.00000000e+00
+ Rs=
+ 1.55902417e-03
+ Gd=
+ 2.04067990e-11

.Model Wmodel_Trace1812::MIPI_DSI1_DATA0_N W MODELTYPE=RLGC N=1
+ Lo=
+ 3.32029740e-07
+ Co=
+ 1.03489020e-10
+ Ro=
+ 3.96831067e+00
+ Go=
+ 0.00000000e+00
+ Rs=
+ 1.55902417e-03
+ Gd=
+ 2.04067990e-11

.Model Wmodel_Trace1812_Auto_2631::MIPI_DSI1_DATA0_N W MODELTYPE=RLGC N=2
+ Lo=
+ 3.30715033e-07
+ 4.26262708e-08 3.30715033e-07
+ Co=
+ 1.03818725e-10
+ -4.59990250e-12 1.03818725e-10
+ Ro=
+ 3.96831067e+00
+ 0.00000000e+00 3.96831067e+00
+ Go=
+ 0.00000000e+00
+ -0.00000000e+00 0.00000000e+00
+ Rs=
+ 1.55902417e-03
+ -0.00000000e+00 1.55902417e-03
+ Gd=
+ 2.03824535e-11
+ -1.83096319e-13 2.03824535e-11

.Model Wmodel_Trace1812_Auto_2632::MIPI_DSI1_DATA0_N W MODELTYPE=RLGC N=1
+ Lo=
+ 3.32029740e-07
+ Co=
+ 1.03489020e-10
+ Ro=
+ 3.96831067e+00
+ Go=
+ 0.00000000e+00
+ Rs=
+ 1.55902417e-03
+ Gd=
+ 2.04067990e-11

.Model Wmodel_Trace1813::MIPI_DSI1_DATA0_N W MODELTYPE=RLGC N=1
+ Lo=
+ 3.32029740e-07
+ Co=
+ 1.03489020e-10
+ Ro=
+ 3.96831067e+00
+ Go=
+ 0.00000000e+00
+ Rs=
+ 1.55902417e-03
+ Gd=
+ 2.04067990e-11

.Model Wmodel_Trace1814::MIPI_DSI1_DATA0_N W MODELTYPE=RLGC N=1
+ Lo=
+ 3.32029740e-07
+ Co=
+ 1.03489020e-10
+ Ro=
+ 3.96831067e+00
+ Go=
+ 0.00000000e+00
+ Rs=
+ 1.55902417e-03
+ Gd=
+ 2.04067990e-11

.Model Wmodel_Trace1814_Auto_2502::MIPI_DSI1_DATA0_N W MODELTYPE=RLGC N=3
+ Lo=
+ 3.30644033e-07
+ 4.16882493e-08 3.28285515e-07
+ 1.40814117e-08 5.53574265e-08 3.29435806e-07
+ Co=
+ 1.03814436e-10
+ -4.45918986e-12 1.04560384e-10
+ -6.01955307e-13 -7.01232440e-12 1.04256808e-10
+ Ro=
+ 3.96831067e+00
+ 0.00000000e+00 3.96831067e+00
+ 0.00000000e+00 0.00000000e+00 3.96831067e+00
+ Go=
+ 0.00000000e+00
+ -0.00000000e+00 0.00000000e+00
+ -0.00000000e+00 -0.00000000e+00 0.00000000e+00
+ Rs=
+ 1.55902417e-03
+ -0.00000000e+00 1.55902417e-03
+ -0.00000000e+00 -0.00000000e+00 1.55902417e-03
+ Gd=
+ 2.03819078e-11
+ -1.81154435e-13 2.03602666e-11
+ -0.00000000e+00 -4.65385346e-13 2.03818724e-11

.Model Wmodel_Trace1814_Auto_2503::MIPI_DSI1_DATA0_N W MODELTYPE=RLGC N=2
+ Lo=
+ 3.30748548e-07
+ 4.21643405e-08 3.30748548e-07
+ Co=
+ 1.03807831e-10
+ -4.52139143e-12 1.03807831e-10
+ Ro=
+ 3.96831067e+00
+ 0.00000000e+00 3.96831067e+00
+ Go=
+ 0.00000000e+00
+ -0.00000000e+00 0.00000000e+00
+ Rs=
+ 1.55902417e-03
+ -0.00000000e+00 1.55902417e-03
+ Gd=
+ 2.03827231e-11
+ -1.75180973e-13 2.03827231e-11

.Model Wmodel_Trace1814_Auto_2504::MIPI_DSI1_DATA0_N W MODELTYPE=RLGC N=1
+ Lo=
+ 3.32029740e-07
+ Co=
+ 1.03489020e-10
+ Ro=
+ 3.96831067e+00
+ Go=
+ 0.00000000e+00
+ Rs=
+ 1.55902417e-03
+ Gd=
+ 2.04067990e-11

.Model Wmodel_Trace1814_Auto_2505::MIPI_DSI1_DATA0_N W MODELTYPE=RLGC N=2
+ Lo=
+ 3.31006394e-07
+ 3.83409681e-08 3.31006394e-07
+ Co=
+ 1.03727316e-10
+ -3.89420171e-12 1.03727316e-10
+ Ro=
+ 3.96831067e+00
+ 0.00000000e+00 3.96831067e+00
+ Go=
+ 0.00000000e+00
+ -0.00000000e+00 0.00000000e+00
+ Rs=
+ 1.55902417e-03
+ -0.00000000e+00 1.55902417e-03
+ Gd=
+ 2.03853867e-11
+ -1.14974238e-13 2.03853867e-11

.Model Wmodel_Trace1815::MIPI_DSI1_DATA0_N W MODELTYPE=RLGC N=1
+ Lo=
+ 3.32029740e-07
+ Co=
+ 1.03489020e-10
+ Ro=
+ 3.96831067e+00
+ Go=
+ 0.00000000e+00
+ Rs=
+ 1.55902417e-03
+ Gd=
+ 2.04067990e-11

.Model Wmodel_Trace1815_Auto_2187::MIPI_DSI1_DATA0_N W MODELTYPE=RLGC N=8
+ Lo=
+ 3.31445725e-07
+ 2.91847354e-08 3.30889619e-07
+ 7.77136919e-09 2.89844281e-08 3.30145626e-07
+ 3.90052172e-09 9.48229447e-09 4.19001653e-08 3.30411010e-07
+ 1.91048083e-09 3.40139072e-09 7.77086033e-09 2.11987406e-08 3.31149709e-07
+ 1.21701814e-09 1.89591378e-09 3.40245362e-09 6.46307639e-09 2.91232026e-08 3.30885822e-07
+ 8.44231268e-10 1.20871377e-09 1.89515991e-09 3.00667447e-09 7.77305238e-09 2.90754781e-08 3.30906055e-07
+ 6.24621037e-10 8.43966487e-10 1.21547226e-09 1.74052091e-09 3.43113978e-09 7.80336620e-09 2.92036183e-08 3.31446920e-07
+ Co=
+ 1.03600036e-10
+ -2.56461201e-12 1.03706943e-10
+ -3.79851624e-13 -2.53561398e-12 1.03918343e-10
+ -1.81146763e-13 -4.44717893e-13 -4.48877867e-12 1.03857922e-10
+ -9.31748387e-14 -1.63871496e-13 -3.72006300e-13 -1.60569834e-12 1.03647260e-10
+ -5.85046446e-14 -8.92552894e-14 -1.55329186e-13 -3.18965679e-13 -2.55667636e-12 1.03707809e-10
+ -4.07349847e-14 -5.69438002e-14 -8.64687657e-14 -1.43330875e-13 -3.81407388e-13 -2.54919780e-12 1.03705844e-10
+ -3.09211307e-14 -4.06820427e-14 -5.66954681e-14 -8.37806242e-14 -1.65931388e-13 -3.85538733e-13 -2.56678428e-12 1.03600048e-10
+ Ro=
+ 3.96831067e+00
+ 0.00000000e+00 3.96831067e+00
+ 0.00000000e+00 0.00000000e+00 3.96831067e+00
+ 0.00000000e+00 0.00000000e+00 0.00000000e+00 3.96831067e+00
+ 0.00000000e+00 0.00000000e+00 0.00000000e+00 0.00000000e+00 3.96831067e+00
+ 0.00000000e+00 0.00000000e+00 0.00000000e+00 0.00000000e+00 0.00000000e+00 3.96831067e+00
+ 0.00000000e+00 0.00000000e+00 0.00000000e+00 0.00000000e+00 0.00000000e+00 0.00000000e+00 3.96831067e+00
+ 0.00000000e+00 0.00000000e+00 0.00000000e+00 0.00000000e+00 0.00000000e+00 0.00000000e+00 0.00000000e+00 3.96831067e+00
+ Go=
+ 0.00000000e+00
+ -0.00000000e+00 0.00000000e+00
+ -0.00000000e+00 -0.00000000e+00 0.00000000e+00
+ -0.00000000e+00 -0.00000000e+00 -0.00000000e+00 0.00000000e+00
+ -0.00000000e+00 -0.00000000e+00 -0.00000000e+00 -0.00000000e+00 0.00000000e+00
+ -0.00000000e+00 -0.00000000e+00 -0.00000000e+00 -0.00000000e+00 -0.00000000e+00 0.00000000e+00
+ -0.00000000e+00 -0.00000000e+00 -0.00000000e+00 -0.00000000e+00 -0.00000000e+00 -0.00000000e+00 0.00000000e+00
+ -0.00000000e+00 -0.00000000e+00 -0.00000000e+00 -0.00000000e+00 -0.00000000e+00 -0.00000000e+00 -0.00000000e+00 0.00000000e+00
+ Rs=
+ 1.55902417e-03
+ -0.00000000e+00 1.55902417e-03
+ -0.00000000e+00 -0.00000000e+00 1.55902417e-03
+ -0.00000000e+00 -0.00000000e+00 -0.00000000e+00 1.55902417e-03
+ -0.00000000e+00 -0.00000000e+00 -0.00000000e+00 -0.00000000e+00 1.55902417e-03
+ -0.00000000e+00 -0.00000000e+00 -0.00000000e+00 -0.00000000e+00 -0.00000000e+00 1.55902417e-03
+ -0.00000000e+00 -0.00000000e+00 -0.00000000e+00 -0.00000000e+00 -0.00000000e+00 -0.00000000e+00 1.55902417e-03
+ -0.00000000e+00 -0.00000000e+00 -0.00000000e+00 -0.00000000e+00 -0.00000000e+00 -0.00000000e+00 -0.00000000e+00 1.55902417e-03
+ Gd=
+ 2.03927200e-11
+ -1.46537770e-14 2.03794568e-11
+ -0.00000000e+00 -1.83913339e-14 2.03689557e-11
+ -0.00000000e+00 -0.00000000e+00 -1.79659967e-13 2.03750576e-11
+ -0.00000000e+00 -0.00000000e+00 -0.00000000e+00 -0.00000000e+00 2.03854471e-11
+ -0.00000000e+00 -0.00000000e+00 -0.00000000e+00 -0.00000000e+00 -1.62738203e-14 2.03792882e-11
+ -0.00000000e+00 -0.00000000e+00 -0.00000000e+00 -0.00000000e+00 -0.00000000e+00 -1.68255914e-14 2.03795837e-11
+ -0.00000000e+00 -0.00000000e+00 -0.00000000e+00 -0.00000000e+00 -0.00000000e+00 -0.00000000e+00 -1.47194650e-14 2.03927234e-11

.Model Wmodel_Trace1815_Auto_2188::MIPI_DSI1_DATA0_N W MODELTYPE=RLGC N=1
+ Lo=
+ 3.32029740e-07
+ Co=
+ 1.03489020e-10
+ Ro=
+ 3.96831067e+00
+ Go=
+ 0.00000000e+00
+ Rs=
+ 1.55902417e-03
+ Gd=
+ 2.04067990e-11

.Model Wmodel_Trace1816::MIPI_DSI1_DATA0_P W MODELTYPE=RLGC N=1
+ Lo=
+ 3.32029740e-07
+ Co=
+ 1.03489020e-10
+ Ro=
+ 3.96831067e+00
+ Go=
+ 0.00000000e+00
+ Rs=
+ 1.55902417e-03
+ Gd=
+ 2.04067990e-11

.Model Wmodel_Trace1817::MIPI_DSI1_DATA0_P W MODELTYPE=RLGC N=1
+ Lo=
+ 3.32029740e-07
+ Co=
+ 1.03489020e-10
+ Ro=
+ 3.96831067e+00
+ Go=
+ 0.00000000e+00
+ Rs=
+ 1.55902417e-03
+ Gd=
+ 2.04067990e-11

.Model Wmodel_Trace1818::MIPI_DSI1_DATA0_P W MODELTYPE=RLGC N=1
+ Lo=
+ 3.32029740e-07
+ Co=
+ 1.03489020e-10
+ Ro=
+ 3.96831067e+00
+ Go=
+ 0.00000000e+00
+ Rs=
+ 1.55902417e-03
+ Gd=
+ 2.04067990e-11

.Model Wmodel_Trace1818_Auto_2137::MIPI_DSI1_DATA0_P W MODELTYPE=RLGC N=2
+ Lo=
+ 3.30714784e-07
+ 4.26296736e-08 3.30714784e-07
+ Co=
+ 1.03818806e-10
+ -4.60048301e-12 1.03818806e-10
+ Ro=
+ 3.96831067e+00
+ 0.00000000e+00 3.96831067e+00
+ Go=
+ 0.00000000e+00
+ -0.00000000e+00 0.00000000e+00
+ Rs=
+ 1.55902417e-03
+ -0.00000000e+00 1.55902417e-03
+ Gd=
+ 2.03824516e-11
+ -1.83155133e-13 2.03824516e-11

.Model Wmodel_Trace1820::MIPI_DSI1_DATA0_P W MODELTYPE=RLGC N=1
+ Lo=
+ 3.32029740e-07
+ Co=
+ 1.03489020e-10
+ Ro=
+ 3.96831067e+00
+ Go=
+ 0.00000000e+00
+ Rs=
+ 1.55902417e-03
+ Gd=
+ 2.04067990e-11

.Model Wmodel_Trace1822::MIPI_DSI1_DATA0_P W MODELTYPE=RLGC N=1
+ Lo=
+ 3.32029740e-07
+ Co=
+ 1.03489020e-10
+ Ro=
+ 3.96831067e+00
+ Go=
+ 0.00000000e+00
+ Rs=
+ 1.55902417e-03
+ Gd=
+ 2.04067990e-11

.Model Wmodel_Trace1822_Auto_2140::MIPI_DSI1_DATA0_P W MODELTYPE=RLGC N=2
+ Lo=
+ 3.30706195e-07
+ 4.27469084e-08 3.30706195e-07
+ Co=
+ 1.03821613e-10
+ -4.62050205e-12 1.03821613e-10
+ Ro=
+ 3.96831067e+00
+ 0.00000000e+00 3.96831067e+00
+ Go=
+ 0.00000000e+00
+ -0.00000000e+00 0.00000000e+00
+ Rs=
+ 1.55902417e-03
+ -0.00000000e+00 1.55902417e-03
+ Gd=
+ 2.03823853e-11
+ -1.85185887e-13 2.03823853e-11

.Model Wmodel_Trace1822_Auto_2141::MIPI_DSI1_DATA0_P W MODELTYPE=RLGC N=1
+ Lo=
+ 3.32029740e-07
+ Co=
+ 1.03489020e-10
+ Ro=
+ 3.96831067e+00
+ Go=
+ 0.00000000e+00
+ Rs=
+ 1.55902417e-03
+ Gd=
+ 2.04067990e-11

.Model Wmodel_Trace1824::MIPI_DSI1_DATA0_P W MODELTYPE=RLGC N=1
+ Lo=
+ 3.32029740e-07
+ Co=
+ 1.03489020e-10
+ Ro=
+ 3.96831067e+00
+ Go=
+ 0.00000000e+00
+ Rs=
+ 1.55902417e-03
+ Gd=
+ 2.04067990e-11

.Model Wmodel_Trace1828::MIPI_DSI1_DATA0_P W MODELTYPE=RLGC N=1
+ Lo=
+ 3.32029740e-07
+ Co=
+ 1.03489020e-10
+ Ro=
+ 3.96831067e+00
+ Go=
+ 0.00000000e+00
+ Rs=
+ 1.55902417e-03
+ Gd=
+ 2.04067990e-11

.Model Wmodel_Trace1837::MIPI_DSI1_DATA0_P W MODELTYPE=RLGC N=1
+ Lo=
+ 3.32029740e-07
+ Co=
+ 1.03489020e-10
+ Ro=
+ 3.96831067e+00
+ Go=
+ 0.00000000e+00
+ Rs=
+ 1.55902417e-03
+ Gd=
+ 2.04067990e-11

.Model Wmodel_Trace1839_Auto_2147::MIPI_DSI1_DATA0_P W MODELTYPE=RLGC N=1
+ Lo=
+ 3.32029740e-07
+ Co=
+ 1.03489020e-10
+ Ro=
+ 3.96831067e+00
+ Go=
+ 0.00000000e+00
+ Rs=
+ 1.55902417e-03
+ Gd=
+ 2.04067990e-11

.Model Wmodel_Trace1841::MIPI_DSI1_DATA0_P W MODELTYPE=RLGC N=1
+ Lo=
+ 3.32029740e-07
+ Co=
+ 1.03489020e-10
+ Ro=
+ 3.96831067e+00
+ Go=
+ 0.00000000e+00
+ Rs=
+ 1.55902417e-03
+ Gd=
+ 2.04067990e-11

.Model Wmodel_Trace1850_Auto_2144::MIPI_DSI1_DATA0_P W MODELTYPE=RLGC N=1
+ Lo=
+ 3.32029740e-07
+ Co=
+ 1.03489020e-10
+ Ro=
+ 3.96831067e+00
+ Go=
+ 0.00000000e+00
+ Rs=
+ 1.55902417e-03
+ Gd=
+ 2.04067990e-11

.Model Wmodel_Trace1859::MIPI_DSI1_DATA0_P W MODELTYPE=RLGC N=1
+ Lo=
+ 3.32029740e-07
+ Co=
+ 1.03489020e-10
+ Ro=
+ 3.96831067e+00
+ Go=
+ 0.00000000e+00
+ Rs=
+ 1.55902417e-03
+ Gd=
+ 2.04067990e-11

.Model Wmodel_Trace1861_Auto_2142::MIPI_DSI1_DATA0_P W MODELTYPE=RLGC N=1
+ Lo=
+ 3.32029740e-07
+ Co=
+ 1.03489020e-10
+ Ro=
+ 3.96831067e+00
+ Go=
+ 0.00000000e+00
+ Rs=
+ 1.55902417e-03
+ Gd=
+ 2.04067990e-11

.Model Wmodel_Trace1861_Auto_2160::MIPI_DSI1_DATA0_P W MODELTYPE=RLGC N=2
+ Lo=
+ 3.31116770e-07
+ 3.65277767e-08 3.31116770e-07
+ Co=
+ 1.03694778e-10
+ -3.61120304e-12 1.03694778e-10
+ Ro=
+ 3.96831067e+00
+ 0.00000000e+00 3.96831067e+00
+ Go=
+ 0.00000000e+00
+ -0.00000000e+00 0.00000000e+00
+ Rs=
+ 1.55902417e-03
+ -0.00000000e+00 1.55902417e-03
+ Gd=
+ 2.03868582e-11
+ -8.98036913e-14 2.03868582e-11

.Model Wmodel_Trace1866::MIPI_DSI1_DATA0_P W MODELTYPE=RLGC N=1
+ Lo=
+ 3.32029740e-07
+ Co=
+ 1.03489020e-10
+ Ro=
+ 3.96831067e+00
+ Go=
+ 0.00000000e+00
+ Rs=
+ 1.55902417e-03
+ Gd=
+ 2.04067990e-11

.Model Wmodel_Trace1868::MIPI_DSI1_DATA0_P W MODELTYPE=RLGC N=2
+ Lo=
+ 3.30715033e-07
+ 4.26262708e-08 3.30715033e-07
+ Co=
+ 1.03818725e-10
+ -4.59990250e-12 1.03818725e-10
+ Ro=
+ 3.96831067e+00
+ 0.00000000e+00 3.96831067e+00
+ Go=
+ 0.00000000e+00
+ -0.00000000e+00 0.00000000e+00
+ Rs=
+ 1.55902417e-03
+ -0.00000000e+00 1.55902417e-03
+ Gd=
+ 2.03824535e-11
+ -1.83096319e-13 2.03824535e-11

.Model Wmodel_Trace1872::MIPI_DSI1_DATA0_P W MODELTYPE=RLGC N=1
+ Lo=
+ 3.32029740e-07
+ Co=
+ 1.03489020e-10
+ Ro=
+ 3.96831067e+00
+ Go=
+ 0.00000000e+00
+ Rs=
+ 1.55902417e-03
+ Gd=
+ 2.04067990e-11

.Model Wmodel_Trace1875::MIPI_DSI1_DATA0_P W MODELTYPE=RLGC N=4
+ Lo=
+ 3.30596478e-07
+ 4.27965572e-08 3.29427604e-07
+ 1.17862324e-08 4.04295368e-08 3.29493428e-07
+ 5.20441597e-09 1.16299214e-08 4.18636161e-08 3.30667043e-07
+ Co=
+ 1.03836379e-10
+ -4.64308880e-12 1.04122319e-10
+ -5.24319694e-13 -4.25141743e-12 1.04100264e-10
+ -2.30422896e-13 -5.18962868e-13 -4.48355986e-12 1.03813918e-10
+ Ro=
+ 3.96831067e+00
+ 0.00000000e+00 3.96831067e+00
+ 0.00000000e+00 0.00000000e+00 3.96831067e+00
+ 0.00000000e+00 0.00000000e+00 0.00000000e+00 3.96831067e+00
+ Go=
+ 0.00000000e+00
+ -0.00000000e+00 0.00000000e+00
+ -0.00000000e+00 -0.00000000e+00 0.00000000e+00
+ -0.00000000e+00 -0.00000000e+00 -0.00000000e+00 0.00000000e+00
+ Rs=
+ 1.55902417e-03
+ -0.00000000e+00 1.55902417e-03
+ -0.00000000e+00 -0.00000000e+00 1.55902417e-03
+ -0.00000000e+00 -0.00000000e+00 -0.00000000e+00 1.55902417e-03
+ Gd=
+ 2.03813611e-11
+ -1.95871759e-13 2.03593107e-11
+ -0.00000000e+00 -1.64324597e-13 2.03597976e-11
+ -0.00000000e+00 -0.00000000e+00 -1.79651864e-13 2.03819044e-11

.Model Wmodel_Trace1875_Auto_2174::MIPI_DSI1_DATA0_P W MODELTYPE=RLGC N=1
+ Lo=
+ 3.32029740e-07
+ Co=
+ 1.03489020e-10
+ Ro=
+ 3.96831067e+00
+ Go=
+ 0.00000000e+00
+ Rs=
+ 1.55902417e-03
+ Gd=
+ 2.04067990e-11

.Model Wmodel_Trace1876::MIPI_DSI1_DATA0_P W MODELTYPE=RLGC N=1
+ Lo=
+ 3.32029740e-07
+ Co=
+ 1.03489020e-10
+ Ro=
+ 3.96831067e+00
+ Go=
+ 0.00000000e+00
+ Rs=
+ 1.55902417e-03
+ Gd=
+ 2.04067990e-11

.Model Wmodel_Trace1878::MIPI_DSI1_DATA0_P W MODELTYPE=RLGC N=1
+ Lo=
+ 3.32029740e-07
+ Co=
+ 1.03489020e-10
+ Ro=
+ 3.96831067e+00
+ Go=
+ 0.00000000e+00
+ Rs=
+ 1.55902417e-03
+ Gd=
+ 2.04067990e-11

.Model Wmodel_Trace1878_Auto_2171::MIPI_DSI1_DATA0_P W MODELTYPE=RLGC N=2
+ Lo=
+ 3.30748904e-07
+ 4.21593990e-08 3.30748904e-07
+ Co=
+ 1.03807716e-10
+ -4.52055469e-12 1.03807716e-10
+ Ro=
+ 3.96831067e+00
+ 0.00000000e+00 3.96831067e+00
+ Go=
+ 0.00000000e+00
+ -0.00000000e+00 0.00000000e+00
+ Rs=
+ 1.55902417e-03
+ -0.00000000e+00 1.55902417e-03
+ Gd=
+ 2.03827260e-11
+ -1.75097034e-13 2.03827260e-11

.Model Wmodel_Trace1878_Auto_2172::MIPI_DSI1_DATA0_P W MODELTYPE=RLGC N=1
+ Lo=
+ 3.32029740e-07
+ Co=
+ 1.03489020e-10
+ Ro=
+ 3.96831067e+00
+ Go=
+ 0.00000000e+00
+ Rs=
+ 1.55902417e-03
+ Gd=
+ 2.04067990e-11

.Model Wmodel_Trace1879::MIPI_DSI1_DATA0_P W MODELTYPE=RLGC N=1
+ Lo=
+ 3.32029740e-07
+ Co=
+ 1.03489020e-10
+ Ro=
+ 3.96831067e+00
+ Go=
+ 0.00000000e+00
+ Rs=
+ 1.55902417e-03
+ Gd=
+ 2.04067990e-11

.Model Wmodel_Trace1879_Auto_2471::MIPI_DSI1_DATA0_P W MODELTYPE=RLGC N=2
+ Lo=
+ 3.30748548e-07
+ 4.21643405e-08 3.30748548e-07
+ Co=
+ 1.03807831e-10
+ -4.52139143e-12 1.03807831e-10
+ Ro=
+ 3.96831067e+00
+ 0.00000000e+00 3.96831067e+00
+ Go=
+ 0.00000000e+00
+ -0.00000000e+00 0.00000000e+00
+ Rs=
+ 1.55902417e-03
+ -0.00000000e+00 1.55902417e-03
+ Gd=
+ 2.03827231e-11
+ -1.75180973e-13 2.03827231e-11

.Model Wmodel_Trace1880::MIPI_DSI1_DATA0_P W MODELTYPE=RLGC N=1
+ Lo=
+ 3.32029740e-07
+ Co=
+ 1.03489020e-10
+ Ro=
+ 3.96831067e+00
+ Go=
+ 0.00000000e+00
+ Rs=
+ 1.55902417e-03
+ Gd=
+ 2.04067990e-11

.Model Wmodel_Trace1880_Auto_2169::MIPI_DSI1_DATA0_P W MODELTYPE=RLGC N=2
+ Lo=
+ 3.31333825e-07
+ 3.25365040e-08 3.31333825e-07
+ Co=
+ 1.03634615e-10
+ -3.02214142e-12 1.03634615e-10
+ Ro=
+ 3.96831067e+00
+ 0.00000000e+00 3.96831067e+00
+ Go=
+ 0.00000000e+00
+ -0.00000000e+00 0.00000000e+00
+ Rs=
+ 1.55902417e-03
+ -0.00000000e+00 1.55902417e-03
+ Gd=
+ 2.03903605e-11
+ -4.22804072e-14 2.03903605e-11

.Model Wmodel_Trace1880_Auto_2170::MIPI_DSI1_DATA0_P W MODELTYPE=RLGC N=1
+ Lo=
+ 3.32029740e-07
+ Co=
+ 1.03489020e-10
+ Ro=
+ 3.96831067e+00
+ Go=
+ 0.00000000e+00
+ Rs=
+ 1.55902417e-03
+ Gd=
+ 2.04067990e-11

.Model Wmodel_Trace1881_Auto_2177::MIPI_DSI1_DATA0_P W MODELTYPE=RLGC N=1
+ Lo=
+ 3.32029740e-07
+ Co=
+ 1.03489020e-10
+ Ro=
+ 3.96831067e+00
+ Go=
+ 0.00000000e+00
+ Rs=
+ 1.55902417e-03
+ Gd=
+ 2.04067990e-11

.Model Wmodel_Trace1885::MIPI_DSI1_DATA0_P W MODELTYPE=RLGC N=1
+ Lo=
+ 3.32029740e-07
+ Co=
+ 1.03489020e-10
+ Ro=
+ 3.96831067e+00
+ Go=
+ 0.00000000e+00
+ Rs=
+ 1.55902417e-03
+ Gd=
+ 2.04067990e-11

.Model Wmodel_Trace1888::MIPI_DSI1_DATA0_P W MODELTYPE=RLGC N=1
+ Lo=
+ 3.32029740e-07
+ Co=
+ 1.03489020e-10
+ Ro=
+ 3.96831067e+00
+ Go=
+ 0.00000000e+00
+ Rs=
+ 1.55902417e-03
+ Gd=
+ 2.04067990e-11

.Model Wmodel_Trace1889::MIPI_DSI1_DATA0_P W MODELTYPE=RLGC N=4
+ Lo=
+ 3.29421011e-07
+ 5.53262110e-08 3.28217837e-07
+ 1.39624744e-08 4.14101819e-08 3.29447399e-07
+ 5.75770467e-09 1.16130572e-08 4.08848603e-08 3.30731790e-07
+ Co=
+ 1.04257870e-10
+ -7.01010666e-12 1.04564919e-10
+ -5.85895143e-13 -4.42362453e-12 1.04105876e-10
+ -2.43511191e-13 -5.11784737e-13 -4.32034461e-12 1.03792262e-10
+ Ro=
+ 3.96831067e+00
+ 0.00000000e+00 3.96831067e+00
+ 0.00000000e+00 0.00000000e+00 3.96831067e+00
+ 0.00000000e+00 0.00000000e+00 0.00000000e+00 3.96831067e+00
+ Go=
+ 0.00000000e+00
+ -0.00000000e+00 0.00000000e+00
+ -0.00000000e+00 -0.00000000e+00 0.00000000e+00
+ -0.00000000e+00 -0.00000000e+00 -0.00000000e+00 0.00000000e+00
+ Rs=
+ 1.55902417e-03
+ -0.00000000e+00 1.55902417e-03
+ -0.00000000e+00 -0.00000000e+00 1.55902417e-03
+ -0.00000000e+00 -0.00000000e+00 -0.00000000e+00 1.55902417e-03
+ Gd=
+ 2.03817322e-11
+ -4.65673465e-13 2.03596725e-11
+ -0.00000000e+00 -1.84933736e-13 2.03595663e-11
+ -0.00000000e+00 -0.00000000e+00 -1.63796361e-13 2.03824939e-11

.Model Wmodel_Trace1891::MIPI_DSI1_DATA0_P W MODELTYPE=RLGC N=1
+ Lo=
+ 3.32029740e-07
+ Co=
+ 1.03489020e-10
+ Ro=
+ 3.96831067e+00
+ Go=
+ 0.00000000e+00
+ Rs=
+ 1.55902417e-03
+ Gd=
+ 2.04067990e-11

.Model Wmodel_Trace1892::MIPI_DSI1_DATA0_P W MODELTYPE=RLGC N=1
+ Lo=
+ 3.32029740e-07
+ Co=
+ 1.03489020e-10
+ Ro=
+ 3.96831067e+00
+ Go=
+ 0.00000000e+00
+ Rs=
+ 1.55902417e-03
+ Gd=
+ 2.04067990e-11

.Model Wmodel_Trace1892_Auto_2186::MIPI_DSI1_DATA0_P W MODELTYPE=RLGC N=1
+ Lo=
+ 3.32029740e-07
+ Co=
+ 1.03489020e-10
+ Ro=
+ 3.96831067e+00
+ Go=
+ 0.00000000e+00
+ Rs=
+ 1.55902417e-03
+ Gd=
+ 2.04067990e-11

.Model Wmodel_Trace1896::MIPI_DSI1_DATA0_P W MODELTYPE=RLGC N=10
+ Lo=
+ 3.57667443e-07
+ 3.74212975e-08 3.56468487e-07
+ 1.17936293e-08 4.60478655e-08 3.56493713e-07
+ 4.87796330e-09 1.13083193e-08 3.52320885e-08 3.56299669e-07
+ 2.89940235e-09 5.39194092e-09 1.16726196e-08 4.87644149e-08 3.56051142e-07
+ 1.83987449e-09 2.95629224e-09 5.12220964e-09 1.28000022e-08 4.07229751e-08 3.56467136e-07
+ 1.27977561e-09 1.87822280e-09 2.87139886e-09 5.51633879e-09 1.16771277e-08 4.17944529e-08 3.56844086e-07
+ 8.96947208e-10 1.22675983e-09 1.71448908e-09 2.78299337e-09 4.63979783e-09 1.01086122e-08 3.21723468e-08 3.56038258e-07
+ 7.17767921e-10 9.45714494e-10 1.26380090e-09 1.89924026e-09 2.86901202e-09 5.19144458e-09 1.17084380e-08 5.43925768e-08 3.55722483e-07
+ 5.72137423e-10 7.27956673e-10 9.34307762e-10 1.31464793e-09 1.83555048e-09 2.89810594e-09 5.17618101e-09 1.37464813e-08 4.09056185e-08 3.57469572e-07
+ Co=
+ 9.38689873e-11
+ -3.05146005e-12 9.41619543e-11
+ -4.59979752e-13 -4.22866676e-12 9.41438378e-11
+ -1.86139240e-13 -4.32483448e-13 -2.77844620e-12 9.42028642e-11
+ -1.07166795e-13 -1.90525437e-13 -4.41762544e-13 -4.63494085e-12 9.42734491e-11
+ -6.94084488e-14 -1.06298970e-13 -1.88693609e-13 -4.79402638e-13 -3.48438889e-12 9.41413349e-11
+ -4.88917787e-14 -6.82400941e-14 -1.05683402e-13 -1.98511883e-13 -4.45963874e-13 -3.63042806e-12 9.40393705e-11
+ -3.40854436e-14 -4.43973308e-14 -6.27491514e-14 -1.00058116e-13 -1.69871920e-13 -3.91758519e-13 -2.41552402e-12 9.43106902e-11
+ -2.66752408e-14 -3.33605597e-14 -4.48345487e-14 -6.59039392e-14 -9.97926121e-14 -1.82385748e-13 -4.41016729e-13 -5.51480328e-12 9.44078654e-11
+ -2.27628888e-14 -2.74679220e-14 -3.53863136e-14 -4.87786524e-14 -6.80321724e-14 -1.08103795e-13 -1.98234839e-13 -5.15559264e-13 -3.50557865e-12 9.39196662e-11
+ Ro=
+ 4.84133902e+00
+ 0.00000000e+00 4.84133902e+00
+ 0.00000000e+00 0.00000000e+00 4.84133902e+00
+ 0.00000000e+00 0.00000000e+00 0.00000000e+00 4.84133902e+00
+ 0.00000000e+00 0.00000000e+00 0.00000000e+00 0.00000000e+00 4.84133902e+00
+ 0.00000000e+00 0.00000000e+00 0.00000000e+00 0.00000000e+00 0.00000000e+00 4.84133902e+00
+ 0.00000000e+00 0.00000000e+00 0.00000000e+00 0.00000000e+00 0.00000000e+00 0.00000000e+00 4.84133902e+00
+ 0.00000000e+00 0.00000000e+00 0.00000000e+00 0.00000000e+00 0.00000000e+00 0.00000000e+00 0.00000000e+00 4.84133902e+00
+ 0.00000000e+00 0.00000000e+00 0.00000000e+00 0.00000000e+00 0.00000000e+00 0.00000000e+00 0.00000000e+00 0.00000000e+00 4.84133902e+00
+ 0.00000000e+00 0.00000000e+00 0.00000000e+00 0.00000000e+00 0.00000000e+00 0.00000000e+00 0.00000000e+00 0.00000000e+00 0.00000000e+00 4.84133902e+00
+ Go=
+ 0.00000000e+00
+ -0.00000000e+00 0.00000000e+00
+ -0.00000000e+00 -0.00000000e+00 0.00000000e+00
+ -0.00000000e+00 -0.00000000e+00 -0.00000000e+00 0.00000000e+00
+ -0.00000000e+00 -0.00000000e+00 -0.00000000e+00 -0.00000000e+00 0.00000000e+00
+ -0.00000000e+00 -0.00000000e+00 -0.00000000e+00 -0.00000000e+00 -0.00000000e+00 0.00000000e+00
+ -0.00000000e+00 -0.00000000e+00 -0.00000000e+00 -0.00000000e+00 -0.00000000e+00 -0.00000000e+00 0.00000000e+00
+ -0.00000000e+00 -0.00000000e+00 -0.00000000e+00 -0.00000000e+00 -0.00000000e+00 -0.00000000e+00 -0.00000000e+00 0.00000000e+00
+ -0.00000000e+00 -0.00000000e+00 -0.00000000e+00 -0.00000000e+00 -0.00000000e+00 -0.00000000e+00 -0.00000000e+00 -0.00000000e+00 0.00000000e+00
+ -0.00000000e+00 -0.00000000e+00 -0.00000000e+00 -0.00000000e+00 -0.00000000e+00 -0.00000000e+00 -0.00000000e+00 -0.00000000e+00 -0.00000000e+00 0.00000000e+00
+ Rs=
+ 1.72420198e-03
+ -0.00000000e+00 1.72420198e-03
+ -0.00000000e+00 -0.00000000e+00 1.72420198e-03
+ -0.00000000e+00 -0.00000000e+00 -0.00000000e+00 1.72420198e-03
+ -0.00000000e+00 -0.00000000e+00 -0.00000000e+00 -0.00000000e+00 1.72420198e-03
+ -0.00000000e+00 -0.00000000e+00 -0.00000000e+00 -0.00000000e+00 -0.00000000e+00 1.72420198e-03
+ -0.00000000e+00 -0.00000000e+00 -0.00000000e+00 -0.00000000e+00 -0.00000000e+00 -0.00000000e+00 1.72420198e-03
+ -0.00000000e+00 -0.00000000e+00 -0.00000000e+00 -0.00000000e+00 -0.00000000e+00 -0.00000000e+00 -0.00000000e+00 1.72420198e-03
+ -0.00000000e+00 -0.00000000e+00 -0.00000000e+00 -0.00000000e+00 -0.00000000e+00 -0.00000000e+00 -0.00000000e+00 -0.00000000e+00 1.72420198e-03
+ -0.00000000e+00 -0.00000000e+00 -0.00000000e+00 -0.00000000e+00 -0.00000000e+00 -0.00000000e+00 -0.00000000e+00 -0.00000000e+00 -0.00000000e+00 1.72420198e-03
+ Gd=
+ 1.82195610e-11
+ -6.68734867e-14 1.81981130e-11
+ -0.00000000e+00 -1.78535490e-13 1.81989132e-11
+ -0.00000000e+00 -0.00000000e+00 -5.22896686e-14 1.81976539e-11
+ -0.00000000e+00 -0.00000000e+00 -0.00000000e+00 -2.22279494e-13 1.81939325e-11
+ -0.00000000e+00 -0.00000000e+00 -0.00000000e+00 -0.00000000e+00 -1.11174156e-13 1.81973565e-11
+ -0.00000000e+00 -0.00000000e+00 -0.00000000e+00 -0.00000000e+00 -0.00000000e+00 -1.20853096e-13 1.82033783e-11
+ -0.00000000e+00 -0.00000000e+00 -0.00000000e+00 -0.00000000e+00 -0.00000000e+00 -0.00000000e+00 -2.62088639e-14 1.81991611e-11
+ -0.00000000e+00 -0.00000000e+00 -0.00000000e+00 -0.00000000e+00 -0.00000000e+00 -0.00000000e+00 -0.00000000e+00 -3.18672381e-13 1.81938002e-11
+ -0.00000000e+00 -0.00000000e+00 -0.00000000e+00 -0.00000000e+00 -0.00000000e+00 -0.00000000e+00 -0.00000000e+00 -0.00000000e+00 -1.08142008e-13 1.82168940e-11

.Model Wmodel_Trace1897::MIPI_DSI1_DATA0_P W MODELTYPE=RLGC N=10
+ Lo=
+ 3.30909316e-07
+ 3.80577566e-08 3.29220618e-07
+ 1.20017289e-08 4.70507171e-08 3.29264272e-07
+ 4.88008425e-09 1.14603212e-08 3.56911935e-08 3.28976972e-07
+ 2.88573512e-09 5.41466373e-09 1.18478477e-08 4.99084704e-08 3.28618268e-07
+ 1.82146969e-09 2.93832040e-09 5.12380094e-09 1.30522940e-08 4.14188573e-08 3.29233302e-07
+ 1.26429696e-09 1.85829252e-09 2.84984709e-09 5.54422850e-09 1.18513220e-08 4.25969568e-08 3.29775874e-07
+ 8.83235514e-10 1.20774358e-09 1.68936545e-09 2.75916795e-09 4.62193375e-09 1.01913207e-08 3.25155206e-08 3.28568026e-07
+ 7.07453511e-10 9.31644702e-10 1.24564199e-09 1.88059212e-09 2.85004780e-09 5.20837672e-09 1.18996830e-08 5.58770257e-08 3.28108165e-07
+ 5.64520395e-10 7.17522595e-10 9.20854152e-10 1.29941710e-09 1.81663047e-09 2.88390005e-09 5.19145694e-09 1.40974523e-08 4.16534601e-08 3.30622147e-07
+ Co=
+ 1.03735824e-10
+ -3.86007468e-12 1.04193867e-10
+ -5.31092870e-13 -5.41457503e-12 1.04163797e-10
+ -2.14822901e-13 -4.96860277e-13 -3.50040174e-12 1.04261228e-10
+ -1.23082022e-13 -2.17020768e-13 -5.06705450e-13 -5.96040406e-12 1.04373980e-10
+ -7.99708980e-14 -1.21399247e-13 -2.16339820e-13 -5.49216107e-13 -4.42914554e-12 1.04157497e-10
+ -5.64621076e-14 -7.80705825e-14 -1.21191263e-13 -2.27035494e-13 -5.12396279e-13 -4.62339450e-12 1.03995640e-10
+ -3.92743804e-14 -5.06800006e-14 -7.17715007e-14 -1.14196047e-13 -1.94265409e-13 -4.50914422e-13 -3.02662239e-12 1.04445368e-10
+ -3.06156618e-14 -3.79137629e-14 -5.10156535e-14 -7.47805919e-14 -1.13243539e-13 -2.07470124e-13 -5.05638267e-13 -7.14375257e-12 1.04600954e-10
+ -2.64706253e-14 -3.16233370e-14 -4.07754924e-14 -5.60507910e-14 -7.81369836e-14 -1.24383622e-13 -2.29176497e-13 -5.91718255e-13 -4.45758521e-12 1.03816506e-10
+ Ro=
+ 3.96831067e+00
+ 0.00000000e+00 3.96831067e+00
+ 0.00000000e+00 0.00000000e+00 3.96831067e+00
+ 0.00000000e+00 0.00000000e+00 0.00000000e+00 3.96831067e+00
+ 0.00000000e+00 0.00000000e+00 0.00000000e+00 0.00000000e+00 3.96831067e+00
+ 0.00000000e+00 0.00000000e+00 0.00000000e+00 0.00000000e+00 0.00000000e+00 3.96831067e+00
+ 0.00000000e+00 0.00000000e+00 0.00000000e+00 0.00000000e+00 0.00000000e+00 0.00000000e+00 3.96831067e+00
+ 0.00000000e+00 0.00000000e+00 0.00000000e+00 0.00000000e+00 0.00000000e+00 0.00000000e+00 0.00000000e+00 3.96831067e+00
+ 0.00000000e+00 0.00000000e+00 0.00000000e+00 0.00000000e+00 0.00000000e+00 0.00000000e+00 0.00000000e+00 0.00000000e+00 3.96831067e+00
+ 0.00000000e+00 0.00000000e+00 0.00000000e+00 0.00000000e+00 0.00000000e+00 0.00000000e+00 0.00000000e+00 0.00000000e+00 0.00000000e+00 3.96831067e+00
+ Go=
+ 0.00000000e+00
+ -0.00000000e+00 0.00000000e+00
+ -0.00000000e+00 -0.00000000e+00 0.00000000e+00
+ -0.00000000e+00 -0.00000000e+00 -0.00000000e+00 0.00000000e+00
+ -0.00000000e+00 -0.00000000e+00 -0.00000000e+00 -0.00000000e+00 0.00000000e+00
+ -0.00000000e+00 -0.00000000e+00 -0.00000000e+00 -0.00000000e+00 -0.00000000e+00 0.00000000e+00
+ -0.00000000e+00 -0.00000000e+00 -0.00000000e+00 -0.00000000e+00 -0.00000000e+00 -0.00000000e+00 0.00000000e+00
+ -0.00000000e+00 -0.00000000e+00 -0.00000000e+00 -0.00000000e+00 -0.00000000e+00 -0.00000000e+00 -0.00000000e+00 0.00000000e+00
+ -0.00000000e+00 -0.00000000e+00 -0.00000000e+00 -0.00000000e+00 -0.00000000e+00 -0.00000000e+00 -0.00000000e+00 -0.00000000e+00 0.00000000e+00
+ -0.00000000e+00 -0.00000000e+00 -0.00000000e+00 -0.00000000e+00 -0.00000000e+00 -0.00000000e+00 -0.00000000e+00 -0.00000000e+00 -0.00000000e+00 0.00000000e+00
+ Rs=
+ 1.55902417e-03
+ -0.00000000e+00 1.55902417e-03
+ -0.00000000e+00 -0.00000000e+00 1.55902417e-03
+ -0.00000000e+00 -0.00000000e+00 -0.00000000e+00 1.55902417e-03
+ -0.00000000e+00 -0.00000000e+00 -0.00000000e+00 -0.00000000e+00 1.55902417e-03
+ -0.00000000e+00 -0.00000000e+00 -0.00000000e+00 -0.00000000e+00 -0.00000000e+00 1.55902417e-03
+ -0.00000000e+00 -0.00000000e+00 -0.00000000e+00 -0.00000000e+00 -0.00000000e+00 -0.00000000e+00 1.55902417e-03
+ -0.00000000e+00 -0.00000000e+00 -0.00000000e+00 -0.00000000e+00 -0.00000000e+00 -0.00000000e+00 -0.00000000e+00 1.55902417e-03
+ -0.00000000e+00 -0.00000000e+00 -0.00000000e+00 -0.00000000e+00 -0.00000000e+00 -0.00000000e+00 -0.00000000e+00 -0.00000000e+00 1.55902417e-03
+ -0.00000000e+00 -0.00000000e+00 -0.00000000e+00 -0.00000000e+00 -0.00000000e+00 -0.00000000e+00 -0.00000000e+00 -0.00000000e+00 -0.00000000e+00 1.55902417e-03
+ Gd=
+ 2.03844074e-11
+ -1.21514527e-13 2.03593688e-11
+ -0.00000000e+00 -2.84489780e-13 2.03602537e-11
+ -0.00000000e+00 -0.00000000e+00 -9.87944286e-14 2.03600951e-11
+ -0.00000000e+00 -0.00000000e+00 -0.00000000e+00 -3.48338907e-13 2.03562095e-11
+ -0.00000000e+00 -0.00000000e+00 -0.00000000e+00 -0.00000000e+00 -1.85711783e-13 2.03576568e-11
+ -0.00000000e+00 -0.00000000e+00 -0.00000000e+00 -0.00000000e+00 -0.00000000e+00 -2.00433537e-13 2.03642916e-11
+ -0.00000000e+00 -0.00000000e+00 -0.00000000e+00 -0.00000000e+00 -0.00000000e+00 -0.00000000e+00 -5.98606281e-14 2.03660026e-11
+ -0.00000000e+00 -0.00000000e+00 -0.00000000e+00 -0.00000000e+00 -0.00000000e+00 -0.00000000e+00 -0.00000000e+00 -4.88568112e-13 2.03601540e-11
+ -0.00000000e+00 -0.00000000e+00 -0.00000000e+00 -0.00000000e+00 -0.00000000e+00 -0.00000000e+00 -0.00000000e+00 -0.00000000e+00 -1.81957977e-13 2.03816710e-11

.Model Wmodel_Trace1898::MIPI_DSI1_DATA0_P W MODELTYPE=RLGC N=1
+ Lo=
+ 3.32029740e-07
+ Co=
+ 1.03489020e-10
+ Ro=
+ 3.96831067e+00
+ Go=
+ 0.00000000e+00
+ Rs=
+ 1.55902417e-03
+ Gd=
+ 2.04067990e-11

.Model Wmodel_Trace1899::MIPI_DSI1_DATA0_P W MODELTYPE=RLGC N=10
+ Lo=
+ 3.30650111e-07
+ 4.18184405e-08 3.29162535e-07
+ 1.23525407e-08 4.47330113e-08 3.29446982e-07
+ 4.97293867e-09 1.11296387e-08 3.57163007e-08 3.28980617e-07
+ 2.92693251e-09 5.30373336e-09 1.18562725e-08 4.99097234e-08 3.28618699e-07
+ 1.84143989e-09 2.89380192e-09 5.12727576e-09 1.30528208e-08 4.14190368e-08 3.29233376e-07
+ 1.27548961e-09 1.83592842e-09 2.85166855e-09 5.54450855e-09 1.18514166e-08 4.25969952e-08 3.29775894e-07
+ 8.89566623e-10 1.19601104e-09 1.69037820e-09 2.75932576e-09 4.62198666e-09 1.01913418e-08 3.25155313e-08 3.28568032e-07
+ 7.11890861e-10 9.23688632e-10 1.24635948e-09 1.88070485e-09 2.85008541e-09 5.20839160e-09 1.18996905e-08 5.58770296e-08 3.28108168e-07
+ 5.67578957e-10 7.12175080e-10 9.21362762e-10 1.29949771e-09 1.81665723e-09 2.88391053e-09 5.19146212e-09 1.40974550e-08 4.16534620e-08 3.30622148e-07
+ Co=
+ 1.03815343e-10
+ -4.47858139e-12 1.04206358e-10
+ -5.43258434e-13 -4.99610971e-12 1.04098480e-10
+ -2.16214333e-13 -4.85488744e-13 -3.50392429e-12 1.04261057e-10
+ -1.23448043e-13 -2.13589323e-13 -5.08059473e-13 -5.96046254e-12 1.04373961e-10
+ -8.00355105e-14 -1.19900231e-13 -2.17047360e-13 -5.49244398e-13 -4.42915418e-12 1.04157493e-10
+ -5.64262774e-14 -7.72650224e-14 -1.21627659e-13 -2.27052058e-13 -5.12401175e-13 -4.62339663e-12 1.03995639e-10
+ -3.92057309e-14 -5.02302070e-14 -7.20462659e-14 -1.14206066e-13 -1.94268296e-13 -4.50915656e-13 -3.02662305e-12 1.04445368e-10
+ -3.05412657e-14 -3.76090123e-14 -5.12175245e-14 -7.47877758e-14 -1.13245577e-13 -2.07470986e-13 -5.05638726e-13 -7.14375282e-12 1.04600954e-10
+ -2.63902401e-14 -3.13918567e-14 -4.09412430e-14 -5.60565638e-14 -7.81385993e-14 -1.24384298e-13 -2.29176855e-13 -5.91718456e-13 -4.45758534e-12 1.03816506e-10
+ Ro=
+ 3.96831067e+00
+ 0.00000000e+00 3.96831067e+00
+ 0.00000000e+00 0.00000000e+00 3.96831067e+00
+ 0.00000000e+00 0.00000000e+00 0.00000000e+00 3.96831067e+00
+ 0.00000000e+00 0.00000000e+00 0.00000000e+00 0.00000000e+00 3.96831067e+00
+ 0.00000000e+00 0.00000000e+00 0.00000000e+00 0.00000000e+00 0.00000000e+00 3.96831067e+00
+ 0.00000000e+00 0.00000000e+00 0.00000000e+00 0.00000000e+00 0.00000000e+00 0.00000000e+00 3.96831067e+00
+ 0.00000000e+00 0.00000000e+00 0.00000000e+00 0.00000000e+00 0.00000000e+00 0.00000000e+00 0.00000000e+00 3.96831067e+00
+ 0.00000000e+00 0.00000000e+00 0.00000000e+00 0.00000000e+00 0.00000000e+00 0.00000000e+00 0.00000000e+00 0.00000000e+00 3.96831067e+00
+ 0.00000000e+00 0.00000000e+00 0.00000000e+00 0.00000000e+00 0.00000000e+00 0.00000000e+00 0.00000000e+00 0.00000000e+00 0.00000000e+00 3.96831067e+00
+ Go=
+ 0.00000000e+00
+ -0.00000000e+00 0.00000000e+00
+ -0.00000000e+00 -0.00000000e+00 0.00000000e+00
+ -0.00000000e+00 -0.00000000e+00 -0.00000000e+00 0.00000000e+00
+ -0.00000000e+00 -0.00000000e+00 -0.00000000e+00 -0.00000000e+00 0.00000000e+00
+ -0.00000000e+00 -0.00000000e+00 -0.00000000e+00 -0.00000000e+00 -0.00000000e+00 0.00000000e+00
+ -0.00000000e+00 -0.00000000e+00 -0.00000000e+00 -0.00000000e+00 -0.00000000e+00 -0.00000000e+00 0.00000000e+00
+ -0.00000000e+00 -0.00000000e+00 -0.00000000e+00 -0.00000000e+00 -0.00000000e+00 -0.00000000e+00 -0.00000000e+00 0.00000000e+00
+ -0.00000000e+00 -0.00000000e+00 -0.00000000e+00 -0.00000000e+00 -0.00000000e+00 -0.00000000e+00 -0.00000000e+00 -0.00000000e+00 0.00000000e+00
+ -0.00000000e+00 -0.00000000e+00 -0.00000000e+00 -0.00000000e+00 -0.00000000e+00 -0.00000000e+00 -0.00000000e+00 -0.00000000e+00 -0.00000000e+00 0.00000000e+00
+ Rs=
+ 1.55902417e-03
+ -0.00000000e+00 1.55902417e-03
+ -0.00000000e+00 -0.00000000e+00 1.55902417e-03
+ -0.00000000e+00 -0.00000000e+00 -0.00000000e+00 1.55902417e-03
+ -0.00000000e+00 -0.00000000e+00 -0.00000000e+00 -0.00000000e+00 1.55902417e-03
+ -0.00000000e+00 -0.00000000e+00 -0.00000000e+00 -0.00000000e+00 -0.00000000e+00 1.55902417e-03
+ -0.00000000e+00 -0.00000000e+00 -0.00000000e+00 -0.00000000e+00 -0.00000000e+00 -0.00000000e+00 1.55902417e-03
+ -0.00000000e+00 -0.00000000e+00 -0.00000000e+00 -0.00000000e+00 -0.00000000e+00 -0.00000000e+00 -0.00000000e+00 1.55902417e-03
+ -0.00000000e+00 -0.00000000e+00 -0.00000000e+00 -0.00000000e+00 -0.00000000e+00 -0.00000000e+00 -0.00000000e+00 -0.00000000e+00 1.55902417e-03
+ -0.00000000e+00 -0.00000000e+00 -0.00000000e+00 -0.00000000e+00 -0.00000000e+00 -0.00000000e+00 -0.00000000e+00 -0.00000000e+00 -0.00000000e+00 1.55902417e-03
+ Gd=
+ 2.03817723e-11
+ -1.80616720e-13 2.03575268e-11
+ -0.00000000e+00 -2.39896395e-13 2.03608025e-11
+ -0.00000000e+00 -0.00000000e+00 -9.85502757e-14 2.03601110e-11
+ -0.00000000e+00 -0.00000000e+00 -0.00000000e+00 -3.48333678e-13 2.03562112e-11
+ -0.00000000e+00 -0.00000000e+00 -0.00000000e+00 -0.00000000e+00 -1.85711013e-13 2.03576572e-11
+ -0.00000000e+00 -0.00000000e+00 -0.00000000e+00 -0.00000000e+00 -0.00000000e+00 -2.00433332e-13 2.03642917e-11
+ -0.00000000e+00 -0.00000000e+00 -0.00000000e+00 -0.00000000e+00 -0.00000000e+00 -0.00000000e+00 -5.98605574e-14 2.03660027e-11
+ -0.00000000e+00 -0.00000000e+00 -0.00000000e+00 -0.00000000e+00 -0.00000000e+00 -0.00000000e+00 -0.00000000e+00 -4.88568082e-13 2.03601540e-11
+ -0.00000000e+00 -0.00000000e+00 -0.00000000e+00 -0.00000000e+00 -0.00000000e+00 -0.00000000e+00 -0.00000000e+00 -0.00000000e+00 -1.81957959e-13 2.03816710e-11

.Model Wmodel_Trace1900::MIPI_DSI1_DATA0_P W MODELTYPE=RLGC N=6
+ Lo=
+ 3.30588227e-07
+ 4.21052915e-08 3.28179527e-07
+ 1.39598092e-08 5.44587893e-08 3.28115481e-07
+ 5.70855331e-09 1.36788789e-08 4.11508947e-08 3.27980932e-07
+ 3.36441375e-09 6.41271306e-09 1.38740068e-08 5.57328511e-08 3.28071893e-07
+ 2.07615340e-09 3.35198049e-09 5.73414557e-09 1.40533301e-08 4.16405698e-08 3.30619069e-07
+ Co=
+ 1.03827100e-10
+ -4.53517585e-12 1.04557567e-10
+ -5.83955201e-13 -6.86665984e-12 1.04552827e-10
+ -2.39310987e-13 -5.55609918e-13 -4.39632826e-12 1.04607839e-10
+ -1.38180842e-13 -2.41331523e-13 -5.61269309e-13 -7.12796831e-12 1.04602393e-10
+ -9.32234104e-14 -1.38345535e-13 -2.41013675e-13 -5.85712499e-13 -4.45678721e-12 1.03816595e-10
+ Ro=
+ 3.96831067e+00
+ 0.00000000e+00 3.96831067e+00
+ 0.00000000e+00 0.00000000e+00 3.96831067e+00
+ 0.00000000e+00 0.00000000e+00 0.00000000e+00 3.96831067e+00
+ 0.00000000e+00 0.00000000e+00 0.00000000e+00 0.00000000e+00 3.96831067e+00
+ 0.00000000e+00 0.00000000e+00 0.00000000e+00 0.00000000e+00 0.00000000e+00 3.96831067e+00
+ Go=
+ 0.00000000e+00
+ -0.00000000e+00 0.00000000e+00
+ -0.00000000e+00 -0.00000000e+00 0.00000000e+00
+ -0.00000000e+00 -0.00000000e+00 -0.00000000e+00 0.00000000e+00
+ -0.00000000e+00 -0.00000000e+00 -0.00000000e+00 -0.00000000e+00 0.00000000e+00
+ -0.00000000e+00 -0.00000000e+00 -0.00000000e+00 -0.00000000e+00 -0.00000000e+00 0.00000000e+00
+ Rs=
+ 1.55902417e-03
+ -0.00000000e+00 1.55902417e-03
+ -0.00000000e+00 -0.00000000e+00 1.55902417e-03
+ -0.00000000e+00 -0.00000000e+00 -0.00000000e+00 1.55902417e-03
+ -0.00000000e+00 -0.00000000e+00 -0.00000000e+00 -0.00000000e+00 1.55902417e-03
+ -0.00000000e+00 -0.00000000e+00 -0.00000000e+00 -0.00000000e+00 -0.00000000e+00 1.55902417e-03
+ Gd=
+ 2.03814071e-11
+ -1.89522853e-13 2.03587023e-11
+ -0.00000000e+00 -4.57877070e-13 2.03582732e-11
+ -0.00000000e+00 -0.00000000e+00 -1.87553554e-13 2.03593718e-11
+ -0.00000000e+00 -0.00000000e+00 -0.00000000e+00 -4.89825579e-13 2.03600170e-11
+ -0.00000000e+00 -0.00000000e+00 -0.00000000e+00 -0.00000000e+00 -1.81972190e-13 2.03816643e-11

.Model Wmodel_Trace1902::MIPI_DSI1_DATA0_P W MODELTYPE=RLGC N=1
+ Lo=
+ 3.32029740e-07
+ Co=
+ 1.03489020e-10
+ Ro=
+ 3.96831067e+00
+ Go=
+ 0.00000000e+00
+ Rs=
+ 1.55902417e-03
+ Gd=
+ 2.04067990e-11

.Model Wmodel_Trace1904::MIPI_DSI1_DATA0_P W MODELTYPE=RLGC N=2
+ Lo=
+ 3.30748904e-07
+ 4.21593990e-08 3.30748904e-07
+ Co=
+ 1.03807716e-10
+ -4.52055469e-12 1.03807716e-10
+ Ro=
+ 3.96831067e+00
+ 0.00000000e+00 3.96831067e+00
+ Go=
+ 0.00000000e+00
+ -0.00000000e+00 0.00000000e+00
+ Rs=
+ 1.55902417e-03
+ -0.00000000e+00 1.55902417e-03
+ Gd=
+ 2.03827260e-11
+ -1.75097034e-13 2.03827260e-11

.Model Wmodel_Trace1904_Auto_1814::MIPI_DSI1_DATA0_P W MODELTYPE=RLGC N=1
+ Lo=
+ 3.32029740e-07
+ Co=
+ 1.03489020e-10
+ Ro=
+ 3.96831067e+00
+ Go=
+ 0.00000000e+00
+ Rs=
+ 1.55902417e-03
+ Gd=
+ 2.04067990e-11

.Model Wmodel_Trace1908::MIPI_DSI1_DATA0_P W MODELTYPE=RLGC N=1
+ Lo=
+ 3.32029740e-07
+ Co=
+ 1.03489020e-10
+ Ro=
+ 3.96831067e+00
+ Go=
+ 0.00000000e+00
+ Rs=
+ 1.55902417e-03
+ Gd=
+ 2.04067990e-11

.Model Wmodel_Trace1910::MIPI_DSI1_DATA0_P W MODELTYPE=RLGC N=1
+ Lo=
+ 3.32029740e-07
+ Co=
+ 1.03489020e-10
+ Ro=
+ 3.96831067e+00
+ Go=
+ 0.00000000e+00
+ Rs=
+ 1.55902417e-03
+ Gd=
+ 2.04067990e-11

.Model Wmodel_Trace1910_Auto_68::MIPI_DSI1_DATA0_P W MODELTYPE=RLGC N=1
+ Lo=
+ 3.32029740e-07
+ Co=
+ 1.03489020e-10
+ Ro=
+ 3.96831067e+00
+ Go=
+ 0.00000000e+00
+ Rs=
+ 1.55902417e-03
+ Gd=
+ 2.04067990e-11

.Model Wmodel_Trace1919::MIPI_DSI1_DATA0_P W MODELTYPE=RLGC N=1
+ Lo=
+ 3.32029740e-07
+ Co=
+ 1.03489020e-10
+ Ro=
+ 3.96831067e+00
+ Go=
+ 0.00000000e+00
+ Rs=
+ 1.55902417e-03
+ Gd=
+ 2.04067990e-11

.Model Wmodel_Trace1921::MIPI_DSI1_DATA0_P W MODELTYPE=RLGC N=1
+ Lo=
+ 3.32029740e-07
+ Co=
+ 1.03489020e-10
+ Ro=
+ 3.96831067e+00
+ Go=
+ 0.00000000e+00
+ Rs=
+ 1.55902417e-03
+ Gd=
+ 2.04067990e-11

.Model Wmodel_Trace1921_Auto_71::MIPI_DSI1_DATA0_P W MODELTYPE=RLGC N=1
+ Lo=
+ 3.32029740e-07
+ Co=
+ 1.03489020e-10
+ Ro=
+ 3.96831067e+00
+ Go=
+ 0.00000000e+00
+ Rs=
+ 1.55902417e-03
+ Gd=
+ 2.04067990e-11

.Model Wmodel_Trace1924::MIPI_DSI1_DATA0_P W MODELTYPE=RLGC N=1
+ Lo=
+ 3.32029740e-07
+ Co=
+ 1.03489020e-10
+ Ro=
+ 3.96831067e+00
+ Go=
+ 0.00000000e+00
+ Rs=
+ 1.55902417e-03
+ Gd=
+ 2.04067990e-11

.Model Wmodel_Trace1926::MIPI_DSI1_DATA0_P W MODELTYPE=RLGC N=1
+ Lo=
+ 3.32029740e-07
+ Co=
+ 1.03489020e-10
+ Ro=
+ 3.96831067e+00
+ Go=
+ 0.00000000e+00
+ Rs=
+ 1.55902417e-03
+ Gd=
+ 2.04067990e-11

.Model Wmodel_Trace1926_Auto_55::MIPI_DSI1_DATA0_P W MODELTYPE=RLGC N=2
+ Lo=
+ 3.30748904e-07
+ 4.21593990e-08 3.30748904e-07
+ Co=
+ 1.03807716e-10
+ -4.52055469e-12 1.03807716e-10
+ Ro=
+ 3.96831067e+00
+ 0.00000000e+00 3.96831067e+00
+ Go=
+ 0.00000000e+00
+ -0.00000000e+00 0.00000000e+00
+ Rs=
+ 1.55902417e-03
+ -0.00000000e+00 1.55902417e-03
+ Gd=
+ 2.03827260e-11
+ -1.75097034e-13 2.03827260e-11

.Model Wmodel_Trace1926_Auto_56::MIPI_DSI1_DATA0_P W MODELTYPE=RLGC N=1
+ Lo=
+ 3.32029740e-07
+ Co=
+ 1.03489020e-10
+ Ro=
+ 3.96831067e+00
+ Go=
+ 0.00000000e+00
+ Rs=
+ 1.55902417e-03
+ Gd=
+ 2.04067990e-11

.Model Wmodel_Trace1930::MIPI_DSI1_DATA0_P W MODELTYPE=RLGC N=1
+ Lo=
+ 3.32029740e-07
+ Co=
+ 1.03489020e-10
+ Ro=
+ 3.96831067e+00
+ Go=
+ 0.00000000e+00
+ Rs=
+ 1.55902417e-03
+ Gd=
+ 2.04067990e-11

.Model Wmodel_Trace1932::MIPI_DSI1_DATA0_P W MODELTYPE=RLGC N=1
+ Lo=
+ 3.32029740e-07
+ Co=
+ 1.03489020e-10
+ Ro=
+ 3.96831067e+00
+ Go=
+ 0.00000000e+00
+ Rs=
+ 1.55902417e-03
+ Gd=
+ 2.04067990e-11

.Model Wmodel_Trace1932_Auto_59::MIPI_DSI1_DATA0_P W MODELTYPE=RLGC N=1
+ Lo=
+ 3.32029740e-07
+ Co=
+ 1.03489020e-10
+ Ro=
+ 3.96831067e+00
+ Go=
+ 0.00000000e+00
+ Rs=
+ 1.55902417e-03
+ Gd=
+ 2.04067990e-11

.Model Wmodel_Trace1941::MIPI_DSI1_DATA0_P W MODELTYPE=RLGC N=1
+ Lo=
+ 3.32029740e-07
+ Co=
+ 1.03489020e-10
+ Ro=
+ 3.96831067e+00
+ Go=
+ 0.00000000e+00
+ Rs=
+ 1.55902417e-03
+ Gd=
+ 2.04067990e-11

.Model Wmodel_Trace1943::MIPI_DSI1_DATA0_P W MODELTYPE=RLGC N=1
+ Lo=
+ 3.32029740e-07
+ Co=
+ 1.03489020e-10
+ Ro=
+ 3.96831067e+00
+ Go=
+ 0.00000000e+00
+ Rs=
+ 1.55902417e-03
+ Gd=
+ 2.04067990e-11

.Model Wmodel_Trace1943_Auto_62::MIPI_DSI1_DATA0_P W MODELTYPE=RLGC N=1
+ Lo=
+ 3.32029740e-07
+ Co=
+ 1.03489020e-10
+ Ro=
+ 3.96831067e+00
+ Go=
+ 0.00000000e+00
+ Rs=
+ 1.55902417e-03
+ Gd=
+ 2.04067990e-11

.Model Wmodel_Trace1946::MIPI_DSI1_DATA0_P W MODELTYPE=RLGC N=1
+ Lo=
+ 3.32029740e-07
+ Co=
+ 1.03489020e-10
+ Ro=
+ 3.96831067e+00
+ Go=
+ 0.00000000e+00
+ Rs=
+ 1.55902417e-03
+ Gd=
+ 2.04067990e-11

.Model Wmodel_Trace1948::MIPI_DSI1_DATA0_P W MODELTYPE=RLGC N=1
+ Lo=
+ 3.32029740e-07
+ Co=
+ 1.03489020e-10
+ Ro=
+ 3.96831067e+00
+ Go=
+ 0.00000000e+00
+ Rs=
+ 1.55902417e-03
+ Gd=
+ 2.04067990e-11

.Model Wmodel_Trace1948_Auto_378::MIPI_DSI1_DATA0_P W MODELTYPE=RLGC N=2
+ Lo=
+ 3.30812642e-07
+ 4.12604102e-08 3.30812641e-07
+ Co=
+ 1.03787262e-10
+ -4.36944504e-12 1.03787262e-10
+ Ro=
+ 3.96831067e+00
+ 0.00000000e+00 3.96831067e+00
+ Go=
+ 0.00000000e+00
+ -0.00000000e+00 0.00000000e+00
+ Rs=
+ 1.55902417e-03
+ -0.00000000e+00 1.55902417e-03
+ Gd=
+ 2.03832868e-11
+ -1.60087502e-13 2.03832868e-11

.Model Wmodel_Trace1952::MIPI_DSI1_DATA0_P W MODELTYPE=RLGC N=1
+ Lo=
+ 3.32029740e-07
+ Co=
+ 1.03489020e-10
+ Ro=
+ 3.96831067e+00
+ Go=
+ 0.00000000e+00
+ Rs=
+ 1.55902417e-03
+ Gd=
+ 2.04067990e-11

.Model Wmodel_Trace1954::MIPI_DSI1_DATA0_P W MODELTYPE=RLGC N=1
+ Lo=
+ 3.32029740e-07
+ Co=
+ 1.03489020e-10
+ Ro=
+ 3.96831067e+00
+ Go=
+ 0.00000000e+00
+ Rs=
+ 1.55902417e-03
+ Gd=
+ 2.04067990e-11

.Model Wmodel_Trace1954_Auto_370::MIPI_DSI1_DATA0_P W MODELTYPE=RLGC N=1
+ Lo=
+ 3.32029740e-07
+ Co=
+ 1.03489020e-10
+ Ro=
+ 3.96831067e+00
+ Go=
+ 0.00000000e+00
+ Rs=
+ 1.55902417e-03
+ Gd=
+ 2.04067990e-11

.Model Wmodel_Trace1963::MIPI_DSI1_DATA0_P W MODELTYPE=RLGC N=1
+ Lo=
+ 3.32029740e-07
+ Co=
+ 1.03489020e-10
+ Ro=
+ 3.96831067e+00
+ Go=
+ 0.00000000e+00
+ Rs=
+ 1.55902417e-03
+ Gd=
+ 2.04067990e-11

.Model Wmodel_Trace1965::MIPI_DSI1_DATA0_P W MODELTYPE=RLGC N=2
+ Lo=
+ 3.30767852e-07
+ 4.18949879e-08 3.30767852e-07
+ Co=
+ 1.03801599e-10
+ -4.47588018e-12 1.03801599e-10
+ Ro=
+ 3.96831067e+00
+ 0.00000000e+00 3.96831067e+00
+ Go=
+ 0.00000000e+00
+ -0.00000000e+00 0.00000000e+00
+ Rs=
+ 1.55902417e-03
+ -0.00000000e+00 1.55902417e-03
+ Gd=
+ 2.03828862e-11
+ -1.70628493e-13 2.03828862e-11

.Model Wmodel_Trace1969::MIPI_DSI1_DATA0_P W MODELTYPE=RLGC N=1
+ Lo=
+ 3.32029740e-07
+ Co=
+ 1.03489020e-10
+ Ro=
+ 3.96831067e+00
+ Go=
+ 0.00000000e+00
+ Rs=
+ 1.55902417e-03
+ Gd=
+ 2.04067990e-11

.Model Wmodel_Trace1971::MIPI_DSI1_DATA0_P W MODELTYPE=RLGC N=2
+ Lo=
+ 3.30815830e-07
+ 4.12147002e-08 3.30815830e-07
+ Co=
+ 1.03786248e-10
+ -4.36182104e-12 1.03786248e-10
+ Ro=
+ 3.96831067e+00
+ 0.00000000e+00 3.96831067e+00
+ Go=
+ 0.00000000e+00
+ -0.00000000e+00 0.00000000e+00
+ Rs=
+ 1.55902417e-03
+ -0.00000000e+00 1.55902417e-03
+ Gd=
+ 2.03833165e-11
+ -1.59338240e-13 2.03833165e-11

.Model Wmodel_Trace1972#BP0::MIPI_DSI1_DATA0_P W MODELTYPE=RLGC N=2
+ Lo=
+ 3.31141551e-07
+ 3.61029539e-08 3.31141551e-07
+ Co=
+ 1.03687645e-10
+ -3.54627070e-12 1.03687645e-10
+ Ro=
+ 3.96831067e+00
+ 0.00000000e+00 3.96831067e+00
+ Go=
+ 0.00000000e+00
+ -0.00000000e+00 0.00000000e+00
+ Rs=
+ 1.55902417e-03
+ -0.00000000e+00 1.55902417e-03
+ Gd=
+ 2.03872168e-11
+ -8.42269567e-14 2.03872168e-11

.Model Wmodel_Trace1973::MIPI_DSI1_DATA0_P W MODELTYPE=RLGC N=1
+ Lo=
+ 3.32029740e-07
+ Co=
+ 1.03489020e-10
+ Ro=
+ 3.96831067e+00
+ Go=
+ 0.00000000e+00
+ Rs=
+ 1.55902417e-03
+ Gd=
+ 2.04067990e-11

.Model Wmodel_Trace551::MIPI_DSI1_CLK_N W MODELTYPE=RLGC N=1
+ Lo=
+ 3.32029740e-07
+ Co=
+ 1.03489020e-10
+ Ro=
+ 3.96831067e+00
+ Go=
+ 0.00000000e+00
+ Rs=
+ 1.55902417e-03
+ Gd=
+ 2.04067990e-11

.Model Wmodel_Trace553::MIPI_DSI1_CLK_N W MODELTYPE=RLGC N=2
+ Lo=
+ 3.30769440e-07
+ 4.18727259e-08 3.30769440e-07
+ Co=
+ 1.03801088e-10
+ -4.47212757e-12 1.03801088e-10
+ Ro=
+ 3.96831067e+00
+ 0.00000000e+00 3.96831067e+00
+ Go=
+ 0.00000000e+00
+ -0.00000000e+00 0.00000000e+00
+ Rs=
+ 1.55902417e-03
+ -0.00000000e+00 1.55902417e-03
+ Gd=
+ 2.03828998e-11
+ -1.70254314e-13 2.03828998e-11

.Model Wmodel_Trace555::MIPI_DSI1_CLK_N W MODELTYPE=RLGC N=1
+ Lo=
+ 3.32029740e-07
+ Co=
+ 1.03489020e-10
+ Ro=
+ 3.96831067e+00
+ Go=
+ 0.00000000e+00
+ Rs=
+ 1.55902417e-03
+ Gd=
+ 2.04067990e-11

.Model Wmodel_Trace557::MIPI_DSI1_CLK_N W MODELTYPE=RLGC N=1
+ Lo=
+ 3.32029740e-07
+ Co=
+ 1.03489020e-10
+ Ro=
+ 3.96831067e+00
+ Go=
+ 0.00000000e+00
+ Rs=
+ 1.55902417e-03
+ Gd=
+ 2.04067990e-11

.Model Wmodel_Trace557_Auto_515::MIPI_DSI1_CLK_N W MODELTYPE=RLGC N=2
+ Lo=
+ 3.30706772e-07
+ 4.27390456e-08 3.30706772e-07
+ Co=
+ 1.03821424e-10
+ -4.61915822e-12 1.03821424e-10
+ Ro=
+ 3.96831067e+00
+ 0.00000000e+00 3.96831067e+00
+ Go=
+ 0.00000000e+00
+ -0.00000000e+00 0.00000000e+00
+ Rs=
+ 1.55902417e-03
+ -0.00000000e+00 1.55902417e-03
+ Gd=
+ 2.03823897e-11
+ -1.85049413e-13 2.03823897e-11

.Model Wmodel_Trace557_Auto_516::MIPI_DSI1_CLK_N W MODELTYPE=RLGC N=1
+ Lo=
+ 3.32029740e-07
+ Co=
+ 1.03489020e-10
+ Ro=
+ 3.96831067e+00
+ Go=
+ 0.00000000e+00
+ Rs=
+ 1.55902417e-03
+ Gd=
+ 2.04067990e-11

.Model Wmodel_Trace559::MIPI_DSI1_CLK_N W MODELTYPE=RLGC N=1
+ Lo=
+ 3.32029740e-07
+ Co=
+ 1.03489020e-10
+ Ro=
+ 3.96831067e+00
+ Go=
+ 0.00000000e+00
+ Rs=
+ 1.55902417e-03
+ Gd=
+ 2.04067990e-11

.Model Wmodel_Trace561::MIPI_DSI1_CLK_N W MODELTYPE=RLGC N=1
+ Lo=
+ 3.32029740e-07
+ Co=
+ 1.03489020e-10
+ Ro=
+ 3.96831067e+00
+ Go=
+ 0.00000000e+00
+ Rs=
+ 1.55902417e-03
+ Gd=
+ 2.04067990e-11

.Model Wmodel_Trace561_Auto_513::MIPI_DSI1_CLK_N W MODELTYPE=RLGC N=2
+ Lo=
+ 3.30740670e-07
+ 4.22735563e-08 3.30740670e-07
+ Co=
+ 1.03810383e-10
+ -4.53990158e-12 1.03810383e-10
+ Ro=
+ 3.96831067e+00
+ 0.00000000e+00 3.96831067e+00
+ Go=
+ 0.00000000e+00
+ -0.00000000e+00 0.00000000e+00
+ Rs=
+ 1.55902417e-03
+ -0.00000000e+00 1.55902417e-03
+ Gd=
+ 2.03826582e-11
+ -1.77040127e-13 2.03826582e-11

.Model Wmodel_Trace562::MIPI_DSI1_CLK_N W MODELTYPE=RLGC N=1
+ Lo=
+ 3.32029740e-07
+ Co=
+ 1.03489020e-10
+ Ro=
+ 3.96831067e+00
+ Go=
+ 0.00000000e+00
+ Rs=
+ 1.55902417e-03
+ Gd=
+ 2.04067990e-11

.Model Wmodel_Trace573::MIPI_DSI1_CLK_N W MODELTYPE=RLGC N=1
+ Lo=
+ 3.32029740e-07
+ Co=
+ 1.03489020e-10
+ Ro=
+ 3.96831067e+00
+ Go=
+ 0.00000000e+00
+ Rs=
+ 1.55902417e-03
+ Gd=
+ 2.04067990e-11

.Model Wmodel_Trace574_Auto_526::MIPI_DSI1_CLK_N W MODELTYPE=RLGC N=1
+ Lo=
+ 3.32029740e-07
+ Co=
+ 1.03489020e-10
+ Ro=
+ 3.96831067e+00
+ Go=
+ 0.00000000e+00
+ Rs=
+ 1.55902417e-03
+ Gd=
+ 2.04067990e-11

.Model Wmodel_Trace575::MIPI_DSI1_CLK_N W MODELTYPE=RLGC N=1
+ Lo=
+ 3.32029740e-07
+ Co=
+ 1.03489020e-10
+ Ro=
+ 3.96831067e+00
+ Go=
+ 0.00000000e+00
+ Rs=
+ 1.55902417e-03
+ Gd=
+ 2.04067990e-11

.Model Wmodel_Trace584::MIPI_DSI1_CLK_N W MODELTYPE=RLGC N=1
+ Lo=
+ 3.32029740e-07
+ Co=
+ 1.03489020e-10
+ Ro=
+ 3.96831067e+00
+ Go=
+ 0.00000000e+00
+ Rs=
+ 1.55902417e-03
+ Gd=
+ 2.04067990e-11

.Model Wmodel_Trace586::MIPI_DSI1_CLK_N W MODELTYPE=RLGC N=1
+ Lo=
+ 3.32029740e-07
+ Co=
+ 1.03489020e-10
+ Ro=
+ 3.96831067e+00
+ Go=
+ 0.00000000e+00
+ Rs=
+ 1.55902417e-03
+ Gd=
+ 2.04067990e-11

.Model Wmodel_Trace586_Auto_564::MIPI_DSI1_CLK_N W MODELTYPE=RLGC N=3
+ Lo=
+ 3.30051172e-07
+ 4.92950423e-08 3.28847903e-07
+ 1.32455837e-08 4.22520519e-08 3.30622881e-07
+ Co=
+ 1.04024123e-10
+ -5.81762043e-12 1.04340865e-10
+ -5.80432408e-13 -4.55150632e-12 1.03825169e-10
+ Ro=
+ 3.96831067e+00
+ 0.00000000e+00 3.96831067e+00
+ 0.00000000e+00 0.00000000e+00 3.96831067e+00
+ Go=
+ 0.00000000e+00
+ -0.00000000e+00 0.00000000e+00
+ -0.00000000e+00 -0.00000000e+00 0.00000000e+00
+ Rs=
+ 1.55902417e-03
+ -0.00000000e+00 1.55902417e-03
+ -0.00000000e+00 -0.00000000e+00 1.55902417e-03
+ Gd=
+ 2.03795689e-11
+ -3.23777119e-13 2.03574155e-11
+ -0.00000000e+00 -1.88634064e-13 2.03816676e-11

.Model Wmodel_Trace588::MIPI_DSI1_CLK_N W MODELTYPE=RLGC N=1
+ Lo=
+ 3.32029740e-07
+ Co=
+ 1.03489020e-10
+ Ro=
+ 3.96831067e+00
+ Go=
+ 0.00000000e+00
+ Rs=
+ 1.55902417e-03
+ Gd=
+ 2.04067990e-11

.Model Wmodel_Trace598::MIPI_DSI1_CLK_N W MODELTYPE=RLGC N=1
+ Lo=
+ 3.32029740e-07
+ Co=
+ 1.03489020e-10
+ Ro=
+ 3.96831067e+00
+ Go=
+ 0.00000000e+00
+ Rs=
+ 1.55902417e-03
+ Gd=
+ 2.04067990e-11

.Model Wmodel_Trace598_Auto_523::MIPI_DSI1_CLK_N W MODELTYPE=RLGC N=6
+ Lo=
+ 3.30643730e-07
+ 4.17347530e-08 3.28872565e-07
+ 1.28495267e-08 4.79049181e-08 3.28801546e-07
+ 5.43634676e-09 1.27297133e-08 4.13976409e-08 3.29106843e-07
+ 3.02468757e-09 5.54225181e-09 1.21232839e-08 4.42253444e-08 3.29186411e-07
+ 1.91391537e-09 3.02619920e-09 5.26690611e-09 1.22563423e-08 4.18033931e-08 3.30652097e-07
+ Co=
+ 1.03814916e-10
+ -4.46678859e-12 1.04302266e-10
+ -5.54751008e-13 -5.58065521e-12 1.04307032e-10
+ -2.32517705e-13 -5.37879616e-13 -4.42489599e-12 1.04199512e-10
+ -1.29862699e-13 -2.24678137e-13 -5.18671026e-13 -4.90929349e-12 1.04194653e-10
+ -8.65451449e-14 -1.28525421e-13 -2.24836630e-13 -5.37684382e-13 -4.47622161e-12 1.03814850e-10
+ Ro=
+ 3.96831067e+00
+ 0.00000000e+00 3.96831067e+00
+ 0.00000000e+00 0.00000000e+00 3.96831067e+00
+ 0.00000000e+00 0.00000000e+00 0.00000000e+00 3.96831067e+00
+ 0.00000000e+00 0.00000000e+00 0.00000000e+00 0.00000000e+00 3.96831067e+00
+ 0.00000000e+00 0.00000000e+00 0.00000000e+00 0.00000000e+00 0.00000000e+00 3.96831067e+00
+ Go=
+ 0.00000000e+00
+ -0.00000000e+00 0.00000000e+00
+ -0.00000000e+00 -0.00000000e+00 0.00000000e+00
+ -0.00000000e+00 -0.00000000e+00 -0.00000000e+00 0.00000000e+00
+ -0.00000000e+00 -0.00000000e+00 -0.00000000e+00 -0.00000000e+00 0.00000000e+00
+ -0.00000000e+00 -0.00000000e+00 -0.00000000e+00 -0.00000000e+00 -0.00000000e+00 0.00000000e+00
+ Rs=
+ 1.55902417e-03
+ -0.00000000e+00 1.55902417e-03
+ -0.00000000e+00 -0.00000000e+00 1.55902417e-03
+ -0.00000000e+00 -0.00000000e+00 -0.00000000e+00 1.55902417e-03
+ -0.00000000e+00 -0.00000000e+00 -0.00000000e+00 -0.00000000e+00 1.55902417e-03
+ -0.00000000e+00 -0.00000000e+00 -0.00000000e+00 -0.00000000e+00 -0.00000000e+00 1.55902417e-03
+ Gd=
+ 2.03817632e-11
+ -1.80464915e-13 2.03568153e-11
+ -0.00000000e+00 -3.06021805e-13 2.03562205e-11
+ -0.00000000e+00 -0.00000000e+00 -1.85001901e-13 2.03570175e-11
+ -0.00000000e+00 -0.00000000e+00 -0.00000000e+00 -2.32276952e-13 2.03576494e-11
+ -0.00000000e+00 -0.00000000e+00 -0.00000000e+00 -0.00000000e+00 -1.80262204e-13 2.03817954e-11

.Model Wmodel_Trace598_Auto_556::MIPI_DSI1_CLK_N W MODELTYPE=RLGC N=1
+ Lo=
+ 3.32029740e-07
+ Co=
+ 1.03489020e-10
+ Ro=
+ 3.96831067e+00
+ Go=
+ 0.00000000e+00
+ Rs=
+ 1.55902417e-03
+ Gd=
+ 2.04067990e-11

.Model Wmodel_Trace598_Auto_571::MIPI_DSI1_CLK_N W MODELTYPE=RLGC N=6
+ Lo=
+ 3.30643488e-07
+ 4.17342228e-08 3.28871397e-07
+ 1.28480676e-08 4.79016496e-08 3.28792142e-07
+ 5.42901949e-09 1.27125481e-08 4.13454113e-08 3.28791072e-07
+ 3.09565423e-09 5.72450160e-09 1.27143327e-08 4.79128662e-08 3.28868743e-07
+ 1.94832121e-09 3.09618013e-09 5.43074504e-09 1.28542441e-08 4.17566342e-08 3.30641747e-07
+ Co=
+ 1.03814929e-10
+ -4.46676253e-12 1.04302318e-10
+ -5.54673983e-13 -5.58050682e-12 1.04307444e-10
+ -2.31190316e-13 -5.35416287e-13 -4.41839199e-12 1.04307814e-10
+ -1.31245594e-13 -2.28669485e-13 -5.35458306e-13 -5.58262847e-12 1.04303209e-10
+ -8.79903859e-14 -1.31271440e-13 -2.31244883e-13 -5.54857649e-13 -4.47057981e-12 1.03815463e-10
+ Ro=
+ 3.96831067e+00
+ 0.00000000e+00 3.96831067e+00
+ 0.00000000e+00 0.00000000e+00 3.96831067e+00
+ 0.00000000e+00 0.00000000e+00 0.00000000e+00 3.96831067e+00
+ 0.00000000e+00 0.00000000e+00 0.00000000e+00 0.00000000e+00 3.96831067e+00
+ 0.00000000e+00 0.00000000e+00 0.00000000e+00 0.00000000e+00 0.00000000e+00 3.96831067e+00
+ Go=
+ 0.00000000e+00
+ -0.00000000e+00 0.00000000e+00
+ -0.00000000e+00 -0.00000000e+00 0.00000000e+00
+ -0.00000000e+00 -0.00000000e+00 -0.00000000e+00 0.00000000e+00
+ -0.00000000e+00 -0.00000000e+00 -0.00000000e+00 -0.00000000e+00 0.00000000e+00
+ -0.00000000e+00 -0.00000000e+00 -0.00000000e+00 -0.00000000e+00 -0.00000000e+00 0.00000000e+00
+ Rs=
+ 1.55902417e-03
+ -0.00000000e+00 1.55902417e-03
+ -0.00000000e+00 -0.00000000e+00 1.55902417e-03
+ -0.00000000e+00 -0.00000000e+00 -0.00000000e+00 1.55902417e-03
+ -0.00000000e+00 -0.00000000e+00 -0.00000000e+00 -0.00000000e+00 1.55902417e-03
+ -0.00000000e+00 -0.00000000e+00 -0.00000000e+00 -0.00000000e+00 -0.00000000e+00 1.55902417e-03
+ Gd=
+ 2.03817622e-11
+ -1.80467059e-13 2.03568111e-11
+ -0.00000000e+00 -3.06034371e-13 2.03561844e-11
+ -0.00000000e+00 -0.00000000e+00 -1.85444628e-13 2.03561837e-11
+ -0.00000000e+00 -0.00000000e+00 -0.00000000e+00 -3.06281413e-13 2.03567981e-11
+ -0.00000000e+00 -0.00000000e+00 -0.00000000e+00 -0.00000000e+00 -1.80855679e-13 2.03817481e-11

.Model Wmodel_Trace598_Auto_579::MIPI_DSI1_CLK_N W MODELTYPE=RLGC N=6
+ Lo=
+ 3.30643914e-07
+ 4.17351503e-08 3.28873429e-07
+ 1.28505999e-08 4.79072865e-08 3.28808209e-07
+ 5.44156052e-09 1.27417077e-08 4.14332260e-08 3.29313107e-07
+ 2.97007364e-09 5.40378599e-09 1.16824989e-08 4.15656710e-08 3.29393731e-07
+ 1.88716826e-09 2.97220243e-09 5.14192557e-09 1.18113728e-08 4.18397736e-08 3.30659094e-07
+ Co=
+ 1.03814906e-10
+ -4.46680932e-12 1.04302226e-10
+ -5.54810905e-13 -5.58076943e-12 1.04306720e-10
+ -2.33452881e-13 -5.39603087e-13 -4.42937352e-12 1.04132784e-10
+ -1.28670321e-13 -2.21384454e-13 -5.05412495e-13 -4.44647477e-12 1.04127848e-10
+ -8.54187394e-14 -1.26400447e-13 -2.19923440e-13 -5.24142468e-13 -4.48088024e-12 1.03814502e-10
+ Ro=
+ 3.96831067e+00
+ 0.00000000e+00 3.96831067e+00
+ 0.00000000e+00 0.00000000e+00 3.96831067e+00
+ 0.00000000e+00 0.00000000e+00 0.00000000e+00 3.96831067e+00
+ 0.00000000e+00 0.00000000e+00 0.00000000e+00 0.00000000e+00 3.96831067e+00
+ 0.00000000e+00 0.00000000e+00 0.00000000e+00 0.00000000e+00 0.00000000e+00 3.96831067e+00
+ Go=
+ 0.00000000e+00
+ -0.00000000e+00 0.00000000e+00
+ -0.00000000e+00 -0.00000000e+00 0.00000000e+00
+ -0.00000000e+00 -0.00000000e+00 -0.00000000e+00 0.00000000e+00
+ -0.00000000e+00 -0.00000000e+00 -0.00000000e+00 -0.00000000e+00 0.00000000e+00
+ -0.00000000e+00 -0.00000000e+00 -0.00000000e+00 -0.00000000e+00 -0.00000000e+00 0.00000000e+00
+ Rs=
+ 1.55902417e-03
+ -0.00000000e+00 1.55902417e-03
+ -0.00000000e+00 -0.00000000e+00 1.55902417e-03
+ -0.00000000e+00 -0.00000000e+00 -0.00000000e+00 1.55902417e-03
+ -0.00000000e+00 -0.00000000e+00 -0.00000000e+00 -0.00000000e+00 1.55902417e-03
+ -0.00000000e+00 -0.00000000e+00 -0.00000000e+00 -0.00000000e+00 -0.00000000e+00 1.55902417e-03
+ Gd=
+ 2.03817642e-11
+ -1.80463098e-13 2.03568188e-11
+ -0.00000000e+00 -3.06011573e-13 2.03562492e-11
+ -0.00000000e+00 -0.00000000e+00 -1.84671880e-13 2.03582988e-11
+ -0.00000000e+00 -0.00000000e+00 -0.00000000e+00 -1.84177656e-13 2.03589413e-11
+ -0.00000000e+00 -0.00000000e+00 -0.00000000e+00 -0.00000000e+00 -1.79904341e-13 2.03818297e-11

.Model Wmodel_Trace598_Auto_582::MIPI_DSI1_CLK_N W MODELTYPE=RLGC N=4
+ Lo=
+ 3.30647936e-07
+ 4.17377146e-08 3.28848843e-07
+ 1.29425005e-08 4.84000301e-08 3.28848843e-07
+ 5.52654106e-09 1.29425005e-08 4.17377146e-08 3.30647936e-07
+ Co=
+ 1.03814504e-10
+ -4.46670159e-12 1.04315738e-10
+ -5.58396158e-13 -5.66916550e-12 1.04315738e-10
+ -2.44056777e-13 -5.58396158e-13 -4.46670159e-12 1.03814504e-10
+ Ro=
+ 3.96831067e+00
+ 0.00000000e+00 3.96831067e+00
+ 0.00000000e+00 0.00000000e+00 3.96831067e+00
+ 0.00000000e+00 0.00000000e+00 0.00000000e+00 3.96831067e+00
+ Go=
+ 0.00000000e+00
+ -0.00000000e+00 0.00000000e+00
+ -0.00000000e+00 -0.00000000e+00 0.00000000e+00
+ -0.00000000e+00 -0.00000000e+00 -0.00000000e+00 0.00000000e+00
+ Rs=
+ 1.55902417e-03
+ -0.00000000e+00 1.55902417e-03
+ -0.00000000e+00 -0.00000000e+00 1.55902417e-03
+ -0.00000000e+00 -0.00000000e+00 -0.00000000e+00 1.55902417e-03
+ Gd=
+ 2.03818222e-11
+ -1.80422025e-13 2.03569600e-11
+ -0.00000000e+00 -3.15398897e-13 2.03569600e-11
+ -0.00000000e+00 -0.00000000e+00 -1.80422025e-13 2.03818222e-11

.Model Wmodel_Trace607::MIPI_DSI1_CLK_N W MODELTYPE=RLGC N=1
+ Lo=
+ 3.32029740e-07
+ Co=
+ 1.03489020e-10
+ Ro=
+ 3.96831067e+00
+ Go=
+ 0.00000000e+00
+ Rs=
+ 1.55902417e-03
+ Gd=
+ 2.04067990e-11

.Model Wmodel_Trace610::MIPI_DSI1_CLK_N W MODELTYPE=RLGC N=1
+ Lo=
+ 3.32029740e-07
+ Co=
+ 1.03489020e-10
+ Ro=
+ 3.96831067e+00
+ Go=
+ 0.00000000e+00
+ Rs=
+ 1.55902417e-03
+ Gd=
+ 2.04067990e-11

.Model Wmodel_Trace610_Auto_549::MIPI_DSI1_CLK_N W MODELTYPE=RLGC N=1
+ Lo=
+ 3.32029740e-07
+ Co=
+ 1.03489020e-10
+ Ro=
+ 3.96831067e+00
+ Go=
+ 0.00000000e+00
+ Rs=
+ 1.55902417e-03
+ Gd=
+ 2.04067990e-11

.Model Wmodel_Trace611::MIPI_DSI1_CLK_N W MODELTYPE=RLGC N=1
+ Lo=
+ 3.32029740e-07
+ Co=
+ 1.03489020e-10
+ Ro=
+ 3.96831067e+00
+ Go=
+ 0.00000000e+00
+ Rs=
+ 1.55902417e-03
+ Gd=
+ 2.04067990e-11

.Model Wmodel_Trace627::MIPI_DSI1_CLK_N W MODELTYPE=RLGC N=1
+ Lo=
+ 3.32029740e-07
+ Co=
+ 1.03489020e-10
+ Ro=
+ 3.96831067e+00
+ Go=
+ 0.00000000e+00
+ Rs=
+ 1.55902417e-03
+ Gd=
+ 2.04067990e-11

.Model Wmodel_Trace627_Auto_599::MIPI_DSI1_CLK_N W MODELTYPE=RLGC N=1
+ Lo=
+ 3.32029740e-07
+ Co=
+ 1.03489020e-10
+ Ro=
+ 3.96831067e+00
+ Go=
+ 0.00000000e+00
+ Rs=
+ 1.55902417e-03
+ Gd=
+ 2.04067990e-11

.Model Wmodel_Trace627_Auto_605::MIPI_DSI1_CLK_N W MODELTYPE=RLGC N=1
+ Lo=
+ 3.32029740e-07
+ Co=
+ 1.03489020e-10
+ Ro=
+ 3.96831067e+00
+ Go=
+ 0.00000000e+00
+ Rs=
+ 1.55902417e-03
+ Gd=
+ 2.04067990e-11

.Model Wmodel_Trace628::MIPI_DSI1_CLK_N W MODELTYPE=RLGC N=3
+ Lo=
+ 3.31587567e-07
+ 2.55784545e-08 3.30349560e-07
+ 8.83570978e-09 4.20417720e-08 3.30711674e-07
+ Co=
+ 1.03566624e-10
+ -2.10589529e-12 1.03879955e-10
+ -4.27774166e-13 -4.50570253e-12 1.03810951e-10
+ Ro=
+ 3.96831067e+00
+ 0.00000000e+00 3.96831067e+00
+ 0.00000000e+00 0.00000000e+00 3.96831067e+00
+ Go=
+ 0.00000000e+00
+ -0.00000000e+00 0.00000000e+00
+ -0.00000000e+00 -0.00000000e+00 0.00000000e+00
+ Rs=
+ 1.55902417e-03
+ -0.00000000e+00 1.55902417e-03
+ -0.00000000e+00 -0.00000000e+00 1.55902417e-03
+ Gd=
+ 2.03958887e-11
+ -0.00000000e+00 2.03727829e-11
+ -0.00000000e+00 -1.77263488e-13 2.03822485e-11

.Model Wmodel_Trace628_Auto_1781::MIPI_DSI1_CLK_N W MODELTYPE=RLGC N=3
+ Lo=
+ 3.31509040e-07
+ 2.75212672e-08 3.30275816e-07
+ 9.24783624e-09 4.20251813e-08 3.30707778e-07
+ Co=
+ 1.03584016e-10
+ -2.34637264e-12 1.03896773e-10
+ -4.44546253e-13 -4.50349125e-12 1.03811214e-10
+ Ro=
+ 3.96831067e+00
+ 0.00000000e+00 3.96831067e+00
+ 0.00000000e+00 0.00000000e+00 3.96831067e+00
+ Go=
+ 0.00000000e+00
+ -0.00000000e+00 0.00000000e+00
+ -0.00000000e+00 -0.00000000e+00 0.00000000e+00
+ Rs=
+ 1.55902417e-03
+ -0.00000000e+00 1.55902417e-03
+ -0.00000000e+00 -0.00000000e+00 1.55902417e-03
+ Gd=
+ 2.03941739e-11
+ -3.44290742e-15 2.03711651e-11
+ -0.00000000e+00 -1.77519062e-13 2.03822159e-11

.Model Wmodel_Trace628_Auto_1790::MIPI_DSI1_CLK_N W MODELTYPE=RLGC N=1
+ Lo=
+ 3.32029740e-07
+ Co=
+ 1.03489020e-10
+ Ro=
+ 3.96831067e+00
+ Go=
+ 0.00000000e+00
+ Rs=
+ 1.55902417e-03
+ Gd=
+ 2.04067990e-11

.Model Wmodel_Trace630::MIPI_DSI1_CLK_N W MODELTYPE=RLGC N=1
+ Lo=
+ 3.32029740e-07
+ Co=
+ 1.03489020e-10
+ Ro=
+ 3.96831067e+00
+ Go=
+ 0.00000000e+00
+ Rs=
+ 1.55902417e-03
+ Gd=
+ 2.04067990e-11

.Model Wmodel_Trace632_Auto_1832::MIPI_DSI1_CLK_N W MODELTYPE=RLGC N=1
+ Lo=
+ 3.32029740e-07
+ Co=
+ 1.03489020e-10
+ Ro=
+ 3.96831067e+00
+ Go=
+ 0.00000000e+00
+ Rs=
+ 1.55902417e-03
+ Gd=
+ 2.04067990e-11

.Model Wmodel_Trace633::MIPI_DSI1_CLK_N W MODELTYPE=RLGC N=1
+ Lo=
+ 3.32029740e-07
+ Co=
+ 1.03489020e-10
+ Ro=
+ 3.96831067e+00
+ Go=
+ 0.00000000e+00
+ Rs=
+ 1.55902417e-03
+ Gd=
+ 2.04067990e-11

.Model Wmodel_Trace634::MIPI_DSI1_CLK_N W MODELTYPE=RLGC N=5
+ Lo=
+ 3.31098819e-07
+ 3.56565344e-08 3.30345289e-07
+ 9.29062492e-09 3.26200127e-08 3.28593655e-07
+ 4.89500722e-09 1.19489896e-08 5.58909361e-08 3.28116141e-07
+ 2.77012609e-09 5.21772521e-09 1.41057352e-08 4.16584003e-08 3.30625292e-07
+ Co=
+ 1.03688425e-10
+ -3.48386418e-12 1.03842217e-10
+ -4.32095536e-13 -3.03904296e-12 1.04443591e-10
+ -2.06631626e-13 -5.11367644e-13 -7.14472156e-12 1.04600403e-10
+ -1.26775544e-13 -2.32682401e-13 -5.92380672e-13 -4.45797132e-12 1.03816232e-10
+ Ro=
+ 3.96831067e+00
+ 0.00000000e+00 3.96831067e+00
+ 0.00000000e+00 0.00000000e+00 3.96831067e+00
+ 0.00000000e+00 0.00000000e+00 0.00000000e+00 3.96831067e+00
+ 0.00000000e+00 0.00000000e+00 0.00000000e+00 0.00000000e+00 3.96831067e+00
+ Go=
+ 0.00000000e+00
+ -0.00000000e+00 0.00000000e+00
+ -0.00000000e+00 -0.00000000e+00 0.00000000e+00
+ -0.00000000e+00 -0.00000000e+00 -0.00000000e+00 0.00000000e+00
+ -0.00000000e+00 -0.00000000e+00 -0.00000000e+00 -0.00000000e+00 0.00000000e+00
+ Rs=
+ 1.55902417e-03
+ -0.00000000e+00 1.55902417e-03
+ -0.00000000e+00 -0.00000000e+00 1.55902417e-03
+ -0.00000000e+00 -0.00000000e+00 -0.00000000e+00 1.55902417e-03
+ -0.00000000e+00 -0.00000000e+00 -0.00000000e+00 -0.00000000e+00 1.55902417e-03
+ Gd=
+ 2.03867442e-11
+ -8.43941755e-14 2.03701890e-11
+ -0.00000000e+00 -5.87049440e-14 2.03662147e-11
+ -0.00000000e+00 -0.00000000e+00 -4.88452233e-13 2.03602201e-11
+ -0.00000000e+00 -0.00000000e+00 -0.00000000e+00 -1.81908614e-13 2.03817082e-11

.Model Wmodel_Trace636_Auto_903::MIPI_DSI1_CLK_N W MODELTYPE=RLGC N=1
+ Lo=
+ 3.32029740e-07
+ Co=
+ 1.03489020e-10
+ Ro=
+ 3.96831067e+00
+ Go=
+ 0.00000000e+00
+ Rs=
+ 1.55902417e-03
+ Gd=
+ 2.04067990e-11

.Model Wmodel_Trace636_Auto_919::MIPI_DSI1_CLK_N W MODELTYPE=RLGC N=1
+ Lo=
+ 3.32029740e-07
+ Co=
+ 1.03489020e-10
+ Ro=
+ 3.96831067e+00
+ Go=
+ 0.00000000e+00
+ Rs=
+ 1.55902417e-03
+ Gd=
+ 2.04067990e-11

.Model Wmodel_Trace636_Auto_929::MIPI_DSI1_CLK_N W MODELTYPE=RLGC N=1
+ Lo=
+ 3.32029740e-07
+ Co=
+ 1.03489020e-10
+ Ro=
+ 3.96831067e+00
+ Go=
+ 0.00000000e+00
+ Rs=
+ 1.55902417e-03
+ Gd=
+ 2.04067990e-11

.Model Wmodel_Trace637::MIPI_DSI1_CLK_N W MODELTYPE=RLGC N=1
+ Lo=
+ 3.58484574e-07
+ Co=
+ 9.37055974e-11
+ Ro=
+ 4.84133902e+00
+ Go=
+ 0.00000000e+00
+ Rs=
+ 1.72420198e-03
+ Gd=
+ 1.82370500e-11

.Model Wmodel_Trace638::MIPI_DSI1_CLK_N W MODELTYPE=RLGC N=1
+ Lo=
+ 3.58484574e-07
+ Co=
+ 9.37055974e-11
+ Ro=
+ 4.84133902e+00
+ Go=
+ 0.00000000e+00
+ Rs=
+ 1.72420198e-03
+ Gd=
+ 1.82370500e-11

.Model Wmodel_Trace639::MIPI_DSI1_CLK_N W MODELTYPE=RLGC N=1
+ Lo=
+ 3.32029740e-07
+ Co=
+ 1.03489020e-10
+ Ro=
+ 3.96831067e+00
+ Go=
+ 0.00000000e+00
+ Rs=
+ 1.55902417e-03
+ Gd=
+ 2.04067990e-11

.Model Wmodel_Trace641::MIPI_DSI1_CLK_N W MODELTYPE=RLGC N=1
+ Lo=
+ 3.32029740e-07
+ Co=
+ 1.03489020e-10
+ Ro=
+ 3.96831067e+00
+ Go=
+ 0.00000000e+00
+ Rs=
+ 1.55902417e-03
+ Gd=
+ 2.04067990e-11

.Model Wmodel_Trace643::MIPI_DSI1_CLK_N W MODELTYPE=RLGC N=1
+ Lo=
+ 3.32029740e-07
+ Co=
+ 1.03489020e-10
+ Ro=
+ 3.96831067e+00
+ Go=
+ 0.00000000e+00
+ Rs=
+ 1.55902417e-03
+ Gd=
+ 2.04067990e-11

.Model Wmodel_Trace643_Auto_2491::MIPI_DSI1_CLK_N W MODELTYPE=RLGC N=4
+ Lo=
+ 3.30641185e-07
+ 4.17221559e-08 3.28651304e-07
+ 1.32703161e-08 5.04739492e-08 3.28643425e-07
+ 5.62262381e-09 1.32939998e-08 4.18374298e-08 3.30632444e-07
+ Co=
+ 1.03815118e-10
+ -4.46546338e-12 1.04387211e-10
+ -5.67184207e-13 -6.06597242e-12 1.04389868e-10
+ -2.47788557e-13 -5.67960618e-13 -4.48507454e-12 1.03817845e-10
+ Ro=
+ 3.96831067e+00
+ 0.00000000e+00 3.96831067e+00
+ 0.00000000e+00 0.00000000e+00 3.96831067e+00
+ 0.00000000e+00 0.00000000e+00 0.00000000e+00 3.96831067e+00
+ Go=
+ 0.00000000e+00
+ -0.00000000e+00 0.00000000e+00
+ -0.00000000e+00 -0.00000000e+00 0.00000000e+00
+ -0.00000000e+00 -0.00000000e+00 -0.00000000e+00 0.00000000e+00
+ Rs=
+ 1.55902417e-03
+ -0.00000000e+00 1.55902417e-03
+ -0.00000000e+00 -0.00000000e+00 1.55902417e-03
+ -0.00000000e+00 -0.00000000e+00 -0.00000000e+00 1.55902417e-03
+ Gd=
+ 2.03817916e-11
+ -1.80955629e-13 2.03571680e-11
+ -0.00000000e+00 -3.61209815e-13 2.03571067e-11
+ -0.00000000e+00 -0.00000000e+00 -1.82936135e-13 2.03817210e-11

.Model Wmodel_Trace643_Auto_2495::MIPI_DSI1_CLK_N W MODELTYPE=RLGC N=2
+ Lo=
+ 3.30749474e-07
+ 4.21514791e-08 3.30749474e-07
+ Co=
+ 1.03807531e-10
+ -4.51921379e-12 1.03807531e-10
+ Ro=
+ 3.96831067e+00
+ 0.00000000e+00 3.96831067e+00
+ Go=
+ 0.00000000e+00
+ -0.00000000e+00 0.00000000e+00
+ Rs=
+ 1.55902417e-03
+ -0.00000000e+00 1.55902417e-03
+ Gd=
+ 2.03827308e-11
+ -1.74962538e-13 2.03827308e-11

.Model Wmodel_Trace644_Auto_2626::MIPI_DSI1_CLK_N W MODELTYPE=RLGC N=1
+ Lo=
+ 3.32029740e-07
+ Co=
+ 1.03489020e-10
+ Ro=
+ 3.96831067e+00
+ Go=
+ 0.00000000e+00
+ Rs=
+ 1.55902417e-03
+ Gd=
+ 2.04067990e-11

.Model Wmodel_Trace646::MIPI_DSI1_CLK_N W MODELTYPE=RLGC N=1
+ Lo=
+ 3.32029740e-07
+ Co=
+ 1.03489020e-10
+ Ro=
+ 3.96831067e+00
+ Go=
+ 0.00000000e+00
+ Rs=
+ 1.55902417e-03
+ Gd=
+ 2.04067990e-11

.Model Wmodel_Trace648::MIPI_DSI1_CLK_N W MODELTYPE=RLGC N=1
+ Lo=
+ 3.32029740e-07
+ Co=
+ 1.03489020e-10
+ Ro=
+ 3.96831067e+00
+ Go=
+ 0.00000000e+00
+ Rs=
+ 1.55902417e-03
+ Gd=
+ 2.04067990e-11

.Model Wmodel_Trace650::MIPI_DSI1_CLK_N W MODELTYPE=RLGC N=1
+ Lo=
+ 3.32029740e-07
+ Co=
+ 1.03489020e-10
+ Ro=
+ 3.96831067e+00
+ Go=
+ 0.00000000e+00
+ Rs=
+ 1.55902417e-03
+ Gd=
+ 2.04067990e-11

.Model Wmodel_Trace652::MIPI_DSI1_CLK_N W MODELTYPE=RLGC N=1
+ Lo=
+ 3.32029740e-07
+ Co=
+ 1.03489020e-10
+ Ro=
+ 3.96831067e+00
+ Go=
+ 0.00000000e+00
+ Rs=
+ 1.55902417e-03
+ Gd=
+ 2.04067990e-11

.Model Wmodel_Trace652_Auto_2549::MIPI_DSI1_CLK_N W MODELTYPE=RLGC N=2
+ Lo=
+ 3.30748904e-07
+ 4.21593990e-08 3.30748904e-07
+ Co=
+ 1.03807716e-10
+ -4.52055469e-12 1.03807716e-10
+ Ro=
+ 3.96831067e+00
+ 0.00000000e+00 3.96831067e+00
+ Go=
+ 0.00000000e+00
+ -0.00000000e+00 0.00000000e+00
+ Rs=
+ 1.55902417e-03
+ -0.00000000e+00 1.55902417e-03
+ Gd=
+ 2.03827260e-11
+ -1.75097034e-13 2.03827260e-11

.Model Wmodel_Trace652_Auto_2550::MIPI_DSI1_CLK_N W MODELTYPE=RLGC N=1
+ Lo=
+ 3.32029740e-07
+ Co=
+ 1.03489020e-10
+ Ro=
+ 3.96831067e+00
+ Go=
+ 0.00000000e+00
+ Rs=
+ 1.55902417e-03
+ Gd=
+ 2.04067990e-11

.Model Wmodel_Trace654::MIPI_DSI1_CLK_N W MODELTYPE=RLGC N=1
+ Lo=
+ 3.32029740e-07
+ Co=
+ 1.03489020e-10
+ Ro=
+ 3.96831067e+00
+ Go=
+ 0.00000000e+00
+ Rs=
+ 1.55902417e-03
+ Gd=
+ 2.04067990e-11

.Model Wmodel_Trace659::MIPI_DSI1_CLK_P W MODELTYPE=RLGC N=1
+ Lo=
+ 3.32029740e-07
+ Co=
+ 1.03489020e-10
+ Ro=
+ 3.96831067e+00
+ Go=
+ 0.00000000e+00
+ Rs=
+ 1.55902417e-03
+ Gd=
+ 2.04067990e-11

.Model Wmodel_Trace661#BP0::MIPI_DSI1_CLK_P W MODELTYPE=RLGC N=1
+ Lo=
+ 3.32029740e-07
+ Co=
+ 1.03489020e-10
+ Ro=
+ 3.96831067e+00
+ Go=
+ 0.00000000e+00
+ Rs=
+ 1.55902417e-03
+ Gd=
+ 2.04067990e-11

.Model Wmodel_Trace661#BP0_Auto_512::MIPI_DSI1_CLK_P W MODELTYPE=RLGC N=1
+ Lo=
+ 3.32029740e-07
+ Co=
+ 1.03489020e-10
+ Ro=
+ 3.96831067e+00
+ Go=
+ 0.00000000e+00
+ Rs=
+ 1.55902417e-03
+ Gd=
+ 2.04067990e-11

.Model Wmodel_Trace663::MIPI_DSI1_CLK_P W MODELTYPE=RLGC N=1
+ Lo=
+ 3.32029740e-07
+ Co=
+ 1.03489020e-10
+ Ro=
+ 3.96831067e+00
+ Go=
+ 0.00000000e+00
+ Rs=
+ 1.55902417e-03
+ Gd=
+ 2.04067990e-11

.Model Wmodel_Trace665::MIPI_DSI1_CLK_P W MODELTYPE=RLGC N=1
+ Lo=
+ 3.32029740e-07
+ Co=
+ 1.03489020e-10
+ Ro=
+ 3.96831067e+00
+ Go=
+ 0.00000000e+00
+ Rs=
+ 1.55902417e-03
+ Gd=
+ 2.04067990e-11

.Model Wmodel_Trace667::MIPI_DSI1_CLK_P W MODELTYPE=RLGC N=1
+ Lo=
+ 3.32029740e-07
+ Co=
+ 1.03489020e-10
+ Ro=
+ 3.96831067e+00
+ Go=
+ 0.00000000e+00
+ Rs=
+ 1.55902417e-03
+ Gd=
+ 2.04067990e-11

.Model Wmodel_Trace679::MIPI_DSI1_CLK_P W MODELTYPE=RLGC N=1
+ Lo=
+ 3.32029740e-07
+ Co=
+ 1.03489020e-10
+ Ro=
+ 3.96831067e+00
+ Go=
+ 0.00000000e+00
+ Rs=
+ 1.55902417e-03
+ Gd=
+ 2.04067990e-11

.Model Wmodel_Trace681_Auto_575::MIPI_DSI1_CLK_P W MODELTYPE=RLGC N=1
+ Lo=
+ 3.32029740e-07
+ Co=
+ 1.03489020e-10
+ Ro=
+ 3.96831067e+00
+ Go=
+ 0.00000000e+00
+ Rs=
+ 1.55902417e-03
+ Gd=
+ 2.04067990e-11

.Model Wmodel_Trace682::MIPI_DSI1_CLK_P W MODELTYPE=RLGC N=1
+ Lo=
+ 3.32029740e-07
+ Co=
+ 1.03489020e-10
+ Ro=
+ 3.96831067e+00
+ Go=
+ 0.00000000e+00
+ Rs=
+ 1.55902417e-03
+ Gd=
+ 2.04067990e-11

.Model Wmodel_Trace683_Auto_567::MIPI_DSI1_CLK_P W MODELTYPE=RLGC N=1
+ Lo=
+ 3.32029740e-07
+ Co=
+ 1.03489020e-10
+ Ro=
+ 3.96831067e+00
+ Go=
+ 0.00000000e+00
+ Rs=
+ 1.55902417e-03
+ Gd=
+ 2.04067990e-11

.Model Wmodel_Trace683_Auto_573::MIPI_DSI1_CLK_P W MODELTYPE=RLGC N=1
+ Lo=
+ 3.32029740e-07
+ Co=
+ 1.03489020e-10
+ Ro=
+ 3.96831067e+00
+ Go=
+ 0.00000000e+00
+ Rs=
+ 1.55902417e-03
+ Gd=
+ 2.04067990e-11

.Model Wmodel_Trace685::MIPI_DSI1_CLK_P W MODELTYPE=RLGC N=1
+ Lo=
+ 3.32029740e-07
+ Co=
+ 1.03489020e-10
+ Ro=
+ 3.96831067e+00
+ Go=
+ 0.00000000e+00
+ Rs=
+ 1.55902417e-03
+ Gd=
+ 2.04067990e-11

.Model Wmodel_Trace694::MIPI_DSI1_CLK_P W MODELTYPE=RLGC N=1
+ Lo=
+ 3.32029740e-07
+ Co=
+ 1.03489020e-10
+ Ro=
+ 3.96831067e+00
+ Go=
+ 0.00000000e+00
+ Rs=
+ 1.55902417e-03
+ Gd=
+ 2.04067990e-11

.Model Wmodel_Trace694_Auto_561::MIPI_DSI1_CLK_P W MODELTYPE=RLGC N=1
+ Lo=
+ 3.32029740e-07
+ Co=
+ 1.03489020e-10
+ Ro=
+ 3.96831067e+00
+ Go=
+ 0.00000000e+00
+ Rs=
+ 1.55902417e-03
+ Gd=
+ 2.04067990e-11

.Model Wmodel_Trace694_Auto_563::MIPI_DSI1_CLK_P W MODELTYPE=RLGC N=1
+ Lo=
+ 3.32029740e-07
+ Co=
+ 1.03489020e-10
+ Ro=
+ 3.96831067e+00
+ Go=
+ 0.00000000e+00
+ Rs=
+ 1.55902417e-03
+ Gd=
+ 2.04067990e-11

.Model Wmodel_Trace704::MIPI_DSI1_CLK_P W MODELTYPE=RLGC N=1
+ Lo=
+ 3.32029740e-07
+ Co=
+ 1.03489020e-10
+ Ro=
+ 3.96831067e+00
+ Go=
+ 0.00000000e+00
+ Rs=
+ 1.55902417e-03
+ Gd=
+ 2.04067990e-11

.Model Wmodel_Trace706::MIPI_DSI1_CLK_P W MODELTYPE=RLGC N=1
+ Lo=
+ 3.32029740e-07
+ Co=
+ 1.03489020e-10
+ Ro=
+ 3.96831067e+00
+ Go=
+ 0.00000000e+00
+ Rs=
+ 1.55902417e-03
+ Gd=
+ 2.04067990e-11

.Model Wmodel_Trace706_Auto_558::MIPI_DSI1_CLK_P W MODELTYPE=RLGC N=1
+ Lo=
+ 3.32029740e-07
+ Co=
+ 1.03489020e-10
+ Ro=
+ 3.96831067e+00
+ Go=
+ 0.00000000e+00
+ Rs=
+ 1.55902417e-03
+ Gd=
+ 2.04067990e-11

.Model Wmodel_Trace706_Auto_562::MIPI_DSI1_CLK_P W MODELTYPE=RLGC N=1
+ Lo=
+ 3.32029740e-07
+ Co=
+ 1.03489020e-10
+ Ro=
+ 3.96831067e+00
+ Go=
+ 0.00000000e+00
+ Rs=
+ 1.55902417e-03
+ Gd=
+ 2.04067990e-11

.Model Wmodel_Trace708::MIPI_DSI1_CLK_P W MODELTYPE=RLGC N=1
+ Lo=
+ 3.32029740e-07
+ Co=
+ 1.03489020e-10
+ Ro=
+ 3.96831067e+00
+ Go=
+ 0.00000000e+00
+ Rs=
+ 1.55902417e-03
+ Gd=
+ 2.04067990e-11

.Model Wmodel_Trace711::MIPI_DSI1_CLK_P W MODELTYPE=RLGC N=3
+ Lo=
+ 3.29953054e-07
+ 5.03493504e-08 3.28785870e-07
+ 1.33167390e-08 4.17639393e-08 3.30656359e-07
+ Co=
+ 1.04060147e-10
+ -6.01839676e-12 1.04365496e-10
+ -5.82097672e-13 -4.46883224e-12 1.03813972e-10
+ Ro=
+ 3.96831067e+00
+ 0.00000000e+00 3.96831067e+00
+ 0.00000000e+00 0.00000000e+00 3.96831067e+00
+ Go=
+ 0.00000000e+00
+ -0.00000000e+00 0.00000000e+00
+ -0.00000000e+00 -0.00000000e+00 0.00000000e+00
+ Rs=
+ 1.55902417e-03
+ -0.00000000e+00 1.55902417e-03
+ -0.00000000e+00 -0.00000000e+00 1.55902417e-03
+ Gd=
+ 2.03796478e-11
+ -3.46731846e-13 2.03577948e-11
+ -0.00000000e+00 -1.80576016e-13 2.03819432e-11

.Model Wmodel_Trace712::MIPI_DSI1_CLK_P W MODELTYPE=RLGC N=3
+ Lo=
+ 3.29955120e-07
+ 5.03279148e-08 3.28787866e-07
+ 1.33133924e-08 4.17642499e-08 3.30656411e-07
+ Co=
+ 1.04059392e-10
+ -6.01427763e-12 1.04364749e-10
+ -5.82006606e-13 -4.46887238e-12 1.03813970e-10
+ Ro=
+ 3.96831067e+00
+ 0.00000000e+00 3.96831067e+00
+ 0.00000000e+00 0.00000000e+00 3.96831067e+00
+ Go=
+ 0.00000000e+00
+ -0.00000000e+00 0.00000000e+00
+ -0.00000000e+00 -0.00000000e+00 0.00000000e+00
+ Rs=
+ 1.55902417e-03
+ -0.00000000e+00 1.55902417e-03
+ -0.00000000e+00 -0.00000000e+00 1.55902417e-03
+ Gd=
+ 2.03796451e-11
+ -3.46254405e-13 2.03577910e-11
+ -0.00000000e+00 -1.80573459e-13 2.03819434e-11

.Model Wmodel_Trace715::MIPI_DSI1_CLK_P W MODELTYPE=RLGC N=1
+ Lo=
+ 3.32029740e-07
+ Co=
+ 1.03489020e-10
+ Ro=
+ 3.96831067e+00
+ Go=
+ 0.00000000e+00
+ Rs=
+ 1.55902417e-03
+ Gd=
+ 2.04067990e-11

.Model Wmodel_Trace716::MIPI_DSI1_CLK_P W MODELTYPE=RLGC N=1
+ Lo=
+ 3.32029740e-07
+ Co=
+ 1.03489020e-10
+ Ro=
+ 3.96831067e+00
+ Go=
+ 0.00000000e+00
+ Rs=
+ 1.55902417e-03
+ Gd=
+ 2.04067990e-11

.Model Wmodel_Trace716_Auto_543::MIPI_DSI1_CLK_P W MODELTYPE=RLGC N=1
+ Lo=
+ 3.32029740e-07
+ Co=
+ 1.03489020e-10
+ Ro=
+ 3.96831067e+00
+ Go=
+ 0.00000000e+00
+ Rs=
+ 1.55902417e-03
+ Gd=
+ 2.04067990e-11

.Model Wmodel_Trace722::MIPI_DSI1_CLK_P W MODELTYPE=RLGC N=1
+ Lo=
+ 3.32029740e-07
+ Co=
+ 1.03489020e-10
+ Ro=
+ 3.96831067e+00
+ Go=
+ 0.00000000e+00
+ Rs=
+ 1.55902417e-03
+ Gd=
+ 2.04067990e-11

.Model Wmodel_Trace727::MIPI_DSI1_CLK_P W MODELTYPE=RLGC N=1
+ Lo=
+ 3.32029740e-07
+ Co=
+ 1.03489020e-10
+ Ro=
+ 3.96831067e+00
+ Go=
+ 0.00000000e+00
+ Rs=
+ 1.55902417e-03
+ Gd=
+ 2.04067990e-11

.Model Wmodel_Trace730::MIPI_DSI1_CLK_P W MODELTYPE=RLGC N=1
+ Lo=
+ 3.32029740e-07
+ Co=
+ 1.03489020e-10
+ Ro=
+ 3.96831067e+00
+ Go=
+ 0.00000000e+00
+ Rs=
+ 1.55902417e-03
+ Gd=
+ 2.04067990e-11

.Model Wmodel_Trace730_Auto_539::MIPI_DSI1_CLK_P W MODELTYPE=RLGC N=6
+ Lo=
+ 3.30417960e-07
+ 4.48485237e-08 3.29111064e-07
+ 1.23844637e-08 4.19819328e-08 3.28778137e-07
+ 5.62321834e-09 1.27916594e-08 4.76029131e-08 3.28780877e-07
+ 3.04371176e-09 5.42411780e-09 1.27621001e-08 4.18460794e-08 3.28928444e-07
+ 1.97965903e-09 3.09118235e-09 5.73400163e-09 1.27444903e-08 4.71766225e-08 3.30219130e-07
+ Co=
+ 1.03891563e-10
+ -5.00528026e-12 1.04217041e-10
+ -5.38446258e-13 -4.52278497e-12 1.04312320e-10
+ -2.33585482e-13 -5.39397853e-13 -5.52850529e-12 1.04310025e-10
+ -1.29432597e-13 -2.23812455e-13 -5.37272871e-13 -4.50077341e-12 1.04281142e-10
+ -8.74219256e-14 -1.30812518e-13 -2.36014625e-13 -5.48879882e-13 -5.42694510e-12 1.03959064e-10
+ Ro=
+ 3.96831067e+00
+ 0.00000000e+00 3.96831067e+00
+ 0.00000000e+00 0.00000000e+00 3.96831067e+00
+ 0.00000000e+00 0.00000000e+00 0.00000000e+00 3.96831067e+00
+ 0.00000000e+00 0.00000000e+00 0.00000000e+00 0.00000000e+00 3.96831067e+00
+ 0.00000000e+00 0.00000000e+00 0.00000000e+00 0.00000000e+00 0.00000000e+00 3.96831067e+00
+ Go=
+ 0.00000000e+00
+ -0.00000000e+00 0.00000000e+00
+ -0.00000000e+00 -0.00000000e+00 0.00000000e+00
+ -0.00000000e+00 -0.00000000e+00 -0.00000000e+00 0.00000000e+00
+ -0.00000000e+00 -0.00000000e+00 -0.00000000e+00 -0.00000000e+00 0.00000000e+00
+ -0.00000000e+00 -0.00000000e+00 -0.00000000e+00 -0.00000000e+00 -0.00000000e+00 0.00000000e+00
+ Rs=
+ 1.55902417e-03
+ -0.00000000e+00 1.55902417e-03
+ -0.00000000e+00 -0.00000000e+00 1.55902417e-03
+ -0.00000000e+00 -0.00000000e+00 -0.00000000e+00 1.55902417e-03
+ -0.00000000e+00 -0.00000000e+00 -0.00000000e+00 -0.00000000e+00 1.55902417e-03
+ -0.00000000e+00 -0.00000000e+00 -0.00000000e+00 -0.00000000e+00 -0.00000000e+00 1.55902417e-03
+ Gd=
+ 2.03802658e-11
+ -2.34600465e-13 2.03572003e-11
+ -0.00000000e+00 -1.94627398e-13 2.03559136e-11
+ -0.00000000e+00 -0.00000000e+00 -3.00903715e-13 2.03559507e-11
+ -0.00000000e+00 -0.00000000e+00 -0.00000000e+00 -1.93054198e-13 2.03566797e-11
+ -0.00000000e+00 -0.00000000e+00 -0.00000000e+00 -0.00000000e+00 -2.80513517e-13 2.03795608e-11

.Model Wmodel_Trace730_Auto_552::MIPI_DSI1_CLK_P W MODELTYPE=RLGC N=1
+ Lo=
+ 3.32029740e-07
+ Co=
+ 1.03489020e-10
+ Ro=
+ 3.96831067e+00
+ Go=
+ 0.00000000e+00
+ Rs=
+ 1.55902417e-03
+ Gd=
+ 2.04067990e-11

.Model Wmodel_Trace733::MIPI_DSI1_CLK_P W MODELTYPE=RLGC N=1
+ Lo=
+ 3.32029740e-07
+ Co=
+ 1.03489020e-10
+ Ro=
+ 3.96831067e+00
+ Go=
+ 0.00000000e+00
+ Rs=
+ 1.55902417e-03
+ Gd=
+ 2.04067990e-11

.Model Wmodel_Trace735::MIPI_DSI1_CLK_P W MODELTYPE=RLGC N=1
+ Lo=
+ 3.32029740e-07
+ Co=
+ 1.03489020e-10
+ Ro=
+ 3.96831067e+00
+ Go=
+ 0.00000000e+00
+ Rs=
+ 1.55902417e-03
+ Gd=
+ 2.04067990e-11

.Model Wmodel_Trace735_Auto_595::MIPI_DSI1_CLK_P W MODELTYPE=RLGC N=1
+ Lo=
+ 3.32029740e-07
+ Co=
+ 1.03489020e-10
+ Ro=
+ 3.96831067e+00
+ Go=
+ 0.00000000e+00
+ Rs=
+ 1.55902417e-03
+ Gd=
+ 2.04067990e-11

.Model Wmodel_Trace735_Auto_596::MIPI_DSI1_CLK_P W MODELTYPE=RLGC N=1
+ Lo=
+ 3.32029740e-07
+ Co=
+ 1.03489020e-10
+ Ro=
+ 3.96831067e+00
+ Go=
+ 0.00000000e+00
+ Rs=
+ 1.55902417e-03
+ Gd=
+ 2.04067990e-11

.Model Wmodel_Trace736::MIPI_DSI1_CLK_P W MODELTYPE=RLGC N=1
+ Lo=
+ 3.32029740e-07
+ Co=
+ 1.03489020e-10
+ Ro=
+ 3.96831067e+00
+ Go=
+ 0.00000000e+00
+ Rs=
+ 1.55902417e-03
+ Gd=
+ 2.04067990e-11

.Model Wmodel_Trace736_Auto_1744::MIPI_DSI1_CLK_P W MODELTYPE=RLGC N=4
+ Lo=
+ 3.30699426e-07
+ 4.20070900e-08 3.30235527e-07
+ 9.16042637e-09 2.73121090e-08 3.30235527e-07
+ 4.39539254e-09 9.16042637e-09 4.20070900e-08 3.30699426e-07
+ Co=
+ 1.03811917e-10
+ -4.50196236e-12 1.03900110e-10
+ -4.31096595e-13 -2.31648719e-12 1.03900110e-10
+ -1.97891953e-13 -4.31096595e-13 -4.50196236e-12 1.03811917e-10
+ Ro=
+ 3.96831067e+00
+ 0.00000000e+00 3.96831067e+00
+ 0.00000000e+00 0.00000000e+00 3.96831067e+00
+ 0.00000000e+00 0.00000000e+00 0.00000000e+00 3.96831067e+00
+ Go=
+ 0.00000000e+00
+ -0.00000000e+00 0.00000000e+00
+ -0.00000000e+00 -0.00000000e+00 0.00000000e+00
+ -0.00000000e+00 -0.00000000e+00 -0.00000000e+00 0.00000000e+00
+ Rs=
+ 1.55902417e-03
+ -0.00000000e+00 1.55902417e-03
+ -0.00000000e+00 -0.00000000e+00 1.55902417e-03
+ -0.00000000e+00 -0.00000000e+00 -0.00000000e+00 1.55902417e-03
+ Gd=
+ 2.03821188e-11
+ -1.77728918e-13 2.03707100e-11
+ -0.00000000e+00 -6.95979309e-15 2.03707100e-11
+ -0.00000000e+00 -0.00000000e+00 -1.77728918e-13 2.03821188e-11

.Model Wmodel_Trace736_Auto_1751::MIPI_DSI1_CLK_P W MODELTYPE=RLGC N=4
+ Lo=
+ 3.30699426e-07
+ 4.20070900e-08 3.30235527e-07
+ 9.16042637e-09 2.73121090e-08 3.30235527e-07
+ 4.39539254e-09 9.16042637e-09 4.20070900e-08 3.30699426e-07
+ Co=
+ 1.03811917e-10
+ -4.50196236e-12 1.03900110e-10
+ -4.31096595e-13 -2.31648719e-12 1.03900110e-10
+ -1.97891953e-13 -4.31096595e-13 -4.50196236e-12 1.03811917e-10
+ Ro=
+ 3.96831067e+00
+ 0.00000000e+00 3.96831067e+00
+ 0.00000000e+00 0.00000000e+00 3.96831067e+00
+ 0.00000000e+00 0.00000000e+00 0.00000000e+00 3.96831067e+00
+ Go=
+ 0.00000000e+00
+ -0.00000000e+00 0.00000000e+00
+ -0.00000000e+00 -0.00000000e+00 0.00000000e+00
+ -0.00000000e+00 -0.00000000e+00 -0.00000000e+00 0.00000000e+00
+ Rs=
+ 1.55902417e-03
+ -0.00000000e+00 1.55902417e-03
+ -0.00000000e+00 -0.00000000e+00 1.55902417e-03
+ -0.00000000e+00 -0.00000000e+00 -0.00000000e+00 1.55902417e-03
+ Gd=
+ 2.03821188e-11
+ -1.77728918e-13 2.03707100e-11
+ -0.00000000e+00 -6.95979309e-15 2.03707100e-11
+ -0.00000000e+00 -0.00000000e+00 -1.77728918e-13 2.03821188e-11

.Model Wmodel_Trace736_Auto_1774::MIPI_DSI1_CLK_P W MODELTYPE=RLGC N=4
+ Lo=
+ 3.30699426e-07
+ 4.20070900e-08 3.30235527e-07
+ 9.16042637e-09 2.73121090e-08 3.30235527e-07
+ 4.39539254e-09 9.16042637e-09 4.20070900e-08 3.30699426e-07
+ Co=
+ 1.03811917e-10
+ -4.50196236e-12 1.03900110e-10
+ -4.31096595e-13 -2.31648719e-12 1.03900110e-10
+ -1.97891953e-13 -4.31096595e-13 -4.50196236e-12 1.03811917e-10
+ Ro=
+ 3.96831067e+00
+ 0.00000000e+00 3.96831067e+00
+ 0.00000000e+00 0.00000000e+00 3.96831067e+00
+ 0.00000000e+00 0.00000000e+00 0.00000000e+00 3.96831067e+00
+ Go=
+ 0.00000000e+00
+ -0.00000000e+00 0.00000000e+00
+ -0.00000000e+00 -0.00000000e+00 0.00000000e+00
+ -0.00000000e+00 -0.00000000e+00 -0.00000000e+00 0.00000000e+00
+ Rs=
+ 1.55902417e-03
+ -0.00000000e+00 1.55902417e-03
+ -0.00000000e+00 -0.00000000e+00 1.55902417e-03
+ -0.00000000e+00 -0.00000000e+00 -0.00000000e+00 1.55902417e-03
+ Gd=
+ 2.03821188e-11
+ -1.77728918e-13 2.03707100e-11
+ -0.00000000e+00 -6.95979309e-15 2.03707100e-11
+ -0.00000000e+00 -0.00000000e+00 -1.77728918e-13 2.03821188e-11

.Model Wmodel_Trace736_Auto_1788::MIPI_DSI1_CLK_P W MODELTYPE=RLGC N=1
+ Lo=
+ 3.32029740e-07
+ Co=
+ 1.03489020e-10
+ Ro=
+ 3.96831067e+00
+ Go=
+ 0.00000000e+00
+ Rs=
+ 1.55902417e-03
+ Gd=
+ 2.04067990e-11

.Model Wmodel_Trace738::MIPI_DSI1_CLK_P W MODELTYPE=RLGC N=1
+ Lo=
+ 3.32029740e-07
+ Co=
+ 1.03489020e-10
+ Ro=
+ 3.96831067e+00
+ Go=
+ 0.00000000e+00
+ Rs=
+ 1.55902417e-03
+ Gd=
+ 2.04067990e-11

.Model Wmodel_Trace740::MIPI_DSI1_CLK_P W MODELTYPE=RLGC N=2
+ Lo=
+ 3.30747387e-07
+ 4.21804618e-08 3.30747387e-07
+ Co=
+ 1.03808206e-10
+ -4.52412165e-12 1.03808206e-10
+ Ro=
+ 3.96831067e+00
+ 0.00000000e+00 3.96831067e+00
+ Go=
+ 0.00000000e+00
+ -0.00000000e+00 0.00000000e+00
+ Rs=
+ 1.55902417e-03
+ -0.00000000e+00 1.55902417e-03
+ Gd=
+ 2.03827134e-11
+ -1.75454921e-13 2.03827134e-11

.Model Wmodel_Trace740_Auto_1829::MIPI_DSI1_CLK_P W MODELTYPE=RLGC N=2
+ Lo=
+ 3.30739358e-07
+ 4.22917086e-08 3.30739358e-07
+ Co=
+ 1.03810808e-10
+ -4.54298124e-12 1.03810808e-10
+ Ro=
+ 3.96831067e+00
+ 0.00000000e+00 3.96831067e+00
+ Go=
+ 0.00000000e+00
+ -0.00000000e+00 0.00000000e+00
+ Rs=
+ 1.55902417e-03
+ -0.00000000e+00 1.55902417e-03
+ Gd=
+ 2.03826475e-11
+ -1.77349869e-13 2.03826475e-11

.Model Wmodel_Trace742::MIPI_DSI1_CLK_P W MODELTYPE=RLGC N=1
+ Lo=
+ 3.32029740e-07
+ Co=
+ 1.03489020e-10
+ Ro=
+ 3.96831067e+00
+ Go=
+ 0.00000000e+00
+ Rs=
+ 1.55902417e-03
+ Gd=
+ 2.04067990e-11

.Model Wmodel_Trace744_Auto_901::MIPI_DSI1_CLK_P W MODELTYPE=RLGC N=1
+ Lo=
+ 3.32029740e-07
+ Co=
+ 1.03489020e-10
+ Ro=
+ 3.96831067e+00
+ Go=
+ 0.00000000e+00
+ Rs=
+ 1.55902417e-03
+ Gd=
+ 2.04067990e-11

.Model Wmodel_Trace744_Auto_917::MIPI_DSI1_CLK_P W MODELTYPE=RLGC N=6
+ Lo=
+ 3.30650132e-07
+ 4.19696230e-08 3.29357524e-07
+ 1.19760019e-08 4.23066452e-08 3.29820604e-07
+ 4.68676877e-09 1.01684419e-08 3.25290882e-08 3.28573904e-07
+ 2.89410300e-09 5.20676463e-09 1.19080517e-08 5.58810095e-08 3.28110925e-07
+ 1.84682451e-09 2.88755941e-09 5.19699451e-09 1.41002374e-08 4.16554156e-08 3.30623544e-07
+ Co=
+ 1.03817527e-10
+ -4.50250363e-12 1.04144946e-10
+ -5.33495871e-13 -4.56894553e-12 1.03986037e-10
+ -2.05112577e-13 -4.51159666e-13 -3.02789916e-12 1.04444902e-10
+ -1.20466542e-13 -2.08197421e-13 -5.06381425e-13 -7.14406494e-12 1.04600741e-10
+ -8.36169188e-14 -1.25102232e-13 -2.29712057e-13 -5.91959907e-13 -4.45775080e-12 1.03816377e-10
+ Ro=
+ 3.96831067e+00
+ 0.00000000e+00 3.96831067e+00
+ 0.00000000e+00 0.00000000e+00 3.96831067e+00
+ 0.00000000e+00 0.00000000e+00 0.00000000e+00 3.96831067e+00
+ 0.00000000e+00 0.00000000e+00 0.00000000e+00 0.00000000e+00 3.96831067e+00
+ 0.00000000e+00 0.00000000e+00 0.00000000e+00 0.00000000e+00 0.00000000e+00 3.96831067e+00
+ Go=
+ 0.00000000e+00
+ -0.00000000e+00 0.00000000e+00
+ -0.00000000e+00 -0.00000000e+00 0.00000000e+00
+ -0.00000000e+00 -0.00000000e+00 -0.00000000e+00 0.00000000e+00
+ -0.00000000e+00 -0.00000000e+00 -0.00000000e+00 -0.00000000e+00 0.00000000e+00
+ -0.00000000e+00 -0.00000000e+00 -0.00000000e+00 -0.00000000e+00 -0.00000000e+00 0.00000000e+00
+ Rs=
+ 1.55902417e-03
+ -0.00000000e+00 1.55902417e-03
+ -0.00000000e+00 -0.00000000e+00 1.55902417e-03
+ -0.00000000e+00 -0.00000000e+00 -0.00000000e+00 1.55902417e-03
+ -0.00000000e+00 -0.00000000e+00 -0.00000000e+00 -0.00000000e+00 1.55902417e-03
+ -0.00000000e+00 -0.00000000e+00 -0.00000000e+00 -0.00000000e+00 -0.00000000e+00 1.55902417e-03
+ Gd=
+ 2.03817584e-11
+ -1.82194353e-13 2.03586338e-11
+ -0.00000000e+00 -1.94153164e-13 2.03646528e-11
+ -0.00000000e+00 -0.00000000e+00 -5.97221464e-14 2.03660617e-11
+ -0.00000000e+00 -0.00000000e+00 -0.00000000e+00 -4.88528605e-13 2.03601808e-11
+ -0.00000000e+00 -0.00000000e+00 -0.00000000e+00 -0.00000000e+00 -1.81935948e-13 2.03816892e-11

.Model Wmodel_Trace745::MIPI_DSI1_CLK_P W MODELTYPE=RLGC N=1
+ Lo=
+ 3.58484574e-07
+ Co=
+ 9.37055974e-11
+ Ro=
+ 4.84133902e+00
+ Go=
+ 0.00000000e+00
+ Rs=
+ 1.72420198e-03
+ Gd=
+ 1.82370500e-11

.Model Wmodel_Trace748::MIPI_DSI1_CLK_P W MODELTYPE=RLGC N=2
+ Lo=
+ 3.31790226e-07
+ 2.05024437e-08 3.31790226e-07
+ Co=
+ 1.03528708e-10
+ -1.54416564e-12 1.03528708e-10
+ Ro=
+ 3.96831067e+00
+ 0.00000000e+00 3.96831067e+00
+ Go=
+ 0.00000000e+00
+ -0.00000000e+00 0.00000000e+00
+ Rs=
+ 1.55902417e-03
+ -0.00000000e+00 1.55902417e-03
+ Gd=
+ 2.04004222e-11
+ -0.00000000e+00 2.04004222e-11

.Model Wmodel_Trace748_Auto_2183::MIPI_DSI1_CLK_P W MODELTYPE=RLGC N=1
+ Lo=
+ 3.32029740e-07
+ Co=
+ 1.03489020e-10
+ Ro=
+ 3.96831067e+00
+ Go=
+ 0.00000000e+00
+ Rs=
+ 1.55902417e-03
+ Gd=
+ 2.04067990e-11

.Model Wmodel_Trace749::MIPI_DSI1_CLK_P W MODELTYPE=RLGC N=3
+ Lo=
+ 3.30721949e-07
+ 4.12605445e-08 3.29526193e-07
+ 1.18319395e-08 4.18854433e-08 3.30677748e-07
+ Co=
+ 1.03798808e-10
+ -4.37954403e-12 1.04107291e-10
+ -5.38084546e-13 -4.48484266e-12 1.03813025e-10
+ Ro=
+ 3.96831067e+00
+ 0.00000000e+00 3.96831067e+00
+ 0.00000000e+00 0.00000000e+00 3.96831067e+00
+ Go=
+ 0.00000000e+00
+ -0.00000000e+00 0.00000000e+00
+ -0.00000000e+00 -0.00000000e+00 0.00000000e+00
+ Rs=
+ 1.55902417e-03
+ -0.00000000e+00 1.55902417e-03
+ -0.00000000e+00 -0.00000000e+00 1.55902417e-03
+ Gd=
+ 2.03824097e-11
+ -1.69083885e-13 2.03600979e-11
+ -0.00000000e+00 -1.79437902e-13 2.03820273e-11

.Model Wmodel_Trace751::MIPI_DSI1_CLK_P W MODELTYPE=RLGC N=1
+ Lo=
+ 3.32029740e-07
+ Co=
+ 1.03489020e-10
+ Ro=
+ 3.96831067e+00
+ Go=
+ 0.00000000e+00
+ Rs=
+ 1.55902417e-03
+ Gd=
+ 2.04067990e-11

.Model Wmodel_Trace752::MIPI_DSI1_CLK_P W MODELTYPE=RLGC N=1
+ Lo=
+ 3.32029740e-07
+ Co=
+ 1.03489020e-10
+ Ro=
+ 3.96831067e+00
+ Go=
+ 0.00000000e+00
+ Rs=
+ 1.55902417e-03
+ Gd=
+ 2.04067990e-11

.Model Wmodel_Trace753_Auto_2494::MIPI_DSI1_CLK_P W MODELTYPE=RLGC N=1
+ Lo=
+ 3.32029740e-07
+ Co=
+ 1.03489020e-10
+ Ro=
+ 3.96831067e+00
+ Go=
+ 0.00000000e+00
+ Rs=
+ 1.55902417e-03
+ Gd=
+ 2.04067990e-11

.Model Wmodel_Trace755_Auto_2623::MIPI_DSI1_CLK_P W MODELTYPE=RLGC N=2
+ Lo=
+ 3.30748904e-07
+ 4.21593990e-08 3.30748904e-07
+ Co=
+ 1.03807716e-10
+ -4.52055469e-12 1.03807716e-10
+ Ro=
+ 3.96831067e+00
+ 0.00000000e+00 3.96831067e+00
+ Go=
+ 0.00000000e+00
+ -0.00000000e+00 0.00000000e+00
+ Rs=
+ 1.55902417e-03
+ -0.00000000e+00 1.55902417e-03
+ Gd=
+ 2.03827260e-11
+ -1.75097034e-13 2.03827260e-11

.Model Wmodel_Trace757::MIPI_DSI1_CLK_P W MODELTYPE=RLGC N=1
+ Lo=
+ 3.32029740e-07
+ Co=
+ 1.03489020e-10
+ Ro=
+ 3.96831067e+00
+ Go=
+ 0.00000000e+00
+ Rs=
+ 1.55902417e-03
+ Gd=
+ 2.04067990e-11

.Model Wmodel_Trace759::MIPI_DSI1_CLK_P W MODELTYPE=RLGC N=1
+ Lo=
+ 3.32029740e-07
+ Co=
+ 1.03489020e-10
+ Ro=
+ 3.96831067e+00
+ Go=
+ 0.00000000e+00
+ Rs=
+ 1.55902417e-03
+ Gd=
+ 2.04067990e-11

.Model Wmodel_Trace759_Auto_2509::MIPI_DSI1_CLK_P W MODELTYPE=RLGC N=3
+ Lo=
+ 3.30682578e-07
+ 4.18887174e-08 3.29636738e-07
+ 1.15518578e-08 3.96573167e-08 3.30836133e-07
+ Co=
+ 1.03812467e-10
+ -4.48471199e-12 1.04072473e-10
+ -5.28972262e-13 -4.11366783e-12 1.03763824e-10
+ Ro=
+ 3.96831067e+00
+ 0.00000000e+00 3.96831067e+00
+ 0.00000000e+00 0.00000000e+00 3.96831067e+00
+ Go=
+ 0.00000000e+00
+ -0.00000000e+00 0.00000000e+00
+ -0.00000000e+00 -0.00000000e+00 0.00000000e+00
+ Rs=
+ 1.55902417e-03
+ -0.00000000e+00 1.55902417e-03
+ -0.00000000e+00 -0.00000000e+00 1.55902417e-03
+ Gd=
+ 2.03820549e-11
+ -1.78953579e-13 2.03611329e-11
+ -0.00000000e+00 -1.43137904e-13 2.03835177e-11

.Model Wmodel_Trace759_Auto_2613::MIPI_DSI1_CLK_P W MODELTYPE=RLGC N=2
+ Lo=
+ 3.30741111e-07
+ 4.22674528e-08 3.30741111e-07
+ Co=
+ 1.03810240e-10
+ -4.53886629e-12 1.03810240e-10
+ Ro=
+ 3.96831067e+00
+ 0.00000000e+00 3.96831067e+00
+ Go=
+ 0.00000000e+00
+ -0.00000000e+00 0.00000000e+00
+ Rs=
+ 1.55902417e-03
+ -0.00000000e+00 1.55902417e-03
+ Gd=
+ 2.03826618e-11
+ -1.76936027e-13 2.03826618e-11

.Model Wmodel_Trace759_Auto_2614::MIPI_DSI1_CLK_P W MODELTYPE=RLGC N=1
+ Lo=
+ 3.32029740e-07
+ Co=
+ 1.03489020e-10
+ Ro=
+ 3.96831067e+00
+ Go=
+ 0.00000000e+00
+ Rs=
+ 1.55902417e-03
+ Gd=
+ 2.04067990e-11

.Model Wmodel_Trace761::MIPI_DSI1_CLK_P W MODELTYPE=RLGC N=1
+ Lo=
+ 3.32029740e-07
+ Co=
+ 1.03489020e-10
+ Ro=
+ 3.96831067e+00
+ Go=
+ 0.00000000e+00
+ Rs=
+ 1.55902417e-03
+ Gd=
+ 2.04067990e-11

.Model Wmodel_Trace767::MIPI_DSI1_CLK_P W MODELTYPE=RLGC N=1
+ Lo=
+ 3.32029740e-07
+ Co=
+ 1.03489020e-10
+ Ro=
+ 3.96831067e+00
+ Go=
+ 0.00000000e+00
+ Rs=
+ 1.55902417e-03
+ Gd=
+ 2.04067990e-11

.Model Wmodel_Trace769::MIPI_DSI1_CLK_P W MODELTYPE=RLGC N=2
+ Lo=
+ 3.30751819e-07
+ 4.21188650e-08 3.30751819e-07
+ Co=
+ 1.03806772e-10
+ -4.51369374e-12 1.03806772e-10
+ Ro=
+ 3.96831067e+00
+ 0.00000000e+00 3.96831067e+00
+ Go=
+ 0.00000000e+00
+ -0.00000000e+00 0.00000000e+00
+ Rs=
+ 1.55902417e-03
+ -0.00000000e+00 1.55902417e-03
+ Gd=
+ 2.03827503e-11
+ -1.74409105e-13 2.03827503e-11

.Model Wmodel_Trace769_Auto_2852::MIPI_DSI1_CLK_P W MODELTYPE=RLGC N=1
+ Lo=
+ 3.32029740e-07
+ Co=
+ 1.03489020e-10
+ Ro=
+ 3.96831067e+00
+ Go=
+ 0.00000000e+00
+ Rs=
+ 1.55902417e-03
+ Gd=
+ 2.04067990e-11

.Model Wmodel_Trace778::MIPI_DSI1_CLK_P W MODELTYPE=RLGC N=1
+ Lo=
+ 3.32029740e-07
+ Co=
+ 1.03489020e-10
+ Ro=
+ 3.96831067e+00
+ Go=
+ 0.00000000e+00
+ Rs=
+ 1.55902417e-03
+ Gd=
+ 2.04067990e-11

.Model Wmodel_Trace792::MIPI_DSI1_CLK_P W MODELTYPE=RLGC N=1
+ Lo=
+ 3.32029740e-07
+ Co=
+ 1.03489020e-10
+ Ro=
+ 3.96831067e+00
+ Go=
+ 0.00000000e+00
+ Rs=
+ 1.55902417e-03
+ Gd=
+ 2.04067990e-11

.Model Wmodel_Trace797::MIPI_DSI1_DATA3_N W MODELTYPE=RLGC N=1
+ Lo=
+ 3.58484574e-07
+ Co=
+ 9.37055974e-11
+ Ro=
+ 4.84133902e+00
+ Go=
+ 0.00000000e+00
+ Rs=
+ 1.72420198e-03
+ Gd=
+ 1.82370500e-11

.Model Wmodel_Trace799::MIPI_DSI1_DATA3_N W MODELTYPE=RLGC N=1
+ Lo=
+ 3.58484574e-07
+ Co=
+ 9.37055974e-11
+ Ro=
+ 4.84133902e+00
+ Go=
+ 0.00000000e+00
+ Rs=
+ 1.72420198e-03
+ Gd=
+ 1.82370500e-11

.Model Wmodel_Trace800_Auto_911::MIPI_DSI1_DATA3_N W MODELTYPE=RLGC N=1
+ Lo=
+ 3.32029740e-07
+ Co=
+ 1.03489020e-10
+ Ro=
+ 3.96831067e+00
+ Go=
+ 0.00000000e+00
+ Rs=
+ 1.55902417e-03
+ Gd=
+ 2.04067990e-11

.Model Wmodel_Trace800_Auto_927::MIPI_DSI1_DATA3_N W MODELTYPE=RLGC N=1
+ Lo=
+ 3.32029740e-07
+ Co=
+ 1.03489020e-10
+ Ro=
+ 3.96831067e+00
+ Go=
+ 0.00000000e+00
+ Rs=
+ 1.55902417e-03
+ Gd=
+ 2.04067990e-11

.Model Wmodel_Trace800_Auto_937::MIPI_DSI1_DATA3_N W MODELTYPE=RLGC N=1
+ Lo=
+ 3.32029740e-07
+ Co=
+ 1.03489020e-10
+ Ro=
+ 3.96831067e+00
+ Go=
+ 0.00000000e+00
+ Rs=
+ 1.55902417e-03
+ Gd=
+ 2.04067990e-11

.Model Wmodel_Trace802::MIPI_DSI1_DATA3_N W MODELTYPE=RLGC N=1
+ Lo=
+ 3.32029740e-07
+ Co=
+ 1.03489020e-10
+ Ro=
+ 3.96831067e+00
+ Go=
+ 0.00000000e+00
+ Rs=
+ 1.55902417e-03
+ Gd=
+ 2.04067990e-11

.Model Wmodel_Trace803::MIPI_DSI1_DATA3_N W MODELTYPE=RLGC N=1
+ Lo=
+ 3.32029740e-07
+ Co=
+ 1.03489020e-10
+ Ro=
+ 3.96831067e+00
+ Go=
+ 0.00000000e+00
+ Rs=
+ 1.55902417e-03
+ Gd=
+ 2.04067990e-11

.Model Wmodel_Trace803_Auto_1827::MIPI_DSI1_DATA3_N W MODELTYPE=RLGC N=1
+ Lo=
+ 3.32029740e-07
+ Co=
+ 1.03489020e-10
+ Ro=
+ 3.96831067e+00
+ Go=
+ 0.00000000e+00
+ Rs=
+ 1.55902417e-03
+ Gd=
+ 2.04067990e-11

.Model Wmodel_Trace805::MIPI_DSI1_DATA3_N W MODELTYPE=RLGC N=1
+ Lo=
+ 3.32029740e-07
+ Co=
+ 1.03489020e-10
+ Ro=
+ 3.96831067e+00
+ Go=
+ 0.00000000e+00
+ Rs=
+ 1.55902417e-03
+ Gd=
+ 2.04067990e-11

.Model Wmodel_Trace807::MIPI_DSI1_DATA3_N W MODELTYPE=RLGC N=1
+ Lo=
+ 3.32029740e-07
+ Co=
+ 1.03489020e-10
+ Ro=
+ 3.96831067e+00
+ Go=
+ 0.00000000e+00
+ Rs=
+ 1.55902417e-03
+ Gd=
+ 2.04067990e-11

.Model Wmodel_Trace807_Auto_1794::MIPI_DSI1_DATA3_N W MODELTYPE=RLGC N=1
+ Lo=
+ 3.32029740e-07
+ Co=
+ 1.03489020e-10
+ Ro=
+ 3.96831067e+00
+ Go=
+ 0.00000000e+00
+ Rs=
+ 1.55902417e-03
+ Gd=
+ 2.04067990e-11

.Model Wmodel_Trace809::MIPI_DSI1_DATA3_N W MODELTYPE=RLGC N=1
+ Lo=
+ 3.32029740e-07
+ Co=
+ 1.03489020e-10
+ Ro=
+ 3.96831067e+00
+ Go=
+ 0.00000000e+00
+ Rs=
+ 1.55902417e-03
+ Gd=
+ 2.04067990e-11

.Model Wmodel_Trace811::MIPI_DSI1_DATA3_N W MODELTYPE=RLGC N=1
+ Lo=
+ 3.32029740e-07
+ Co=
+ 1.03489020e-10
+ Ro=
+ 3.96831067e+00
+ Go=
+ 0.00000000e+00
+ Rs=
+ 1.55902417e-03
+ Gd=
+ 2.04067990e-11

.Model Wmodel_Trace815::MIPI_DSI1_DATA3_N W MODELTYPE=RLGC N=1
+ Lo=
+ 3.32029740e-07
+ Co=
+ 1.03489020e-10
+ Ro=
+ 3.96831067e+00
+ Go=
+ 0.00000000e+00
+ Rs=
+ 1.55902417e-03
+ Gd=
+ 2.04067990e-11

.Model Wmodel_Trace816::MIPI_DSI1_DATA3_N W MODELTYPE=RLGC N=1
+ Lo=
+ 3.32029740e-07
+ Co=
+ 1.03489020e-10
+ Ro=
+ 3.96831067e+00
+ Go=
+ 0.00000000e+00
+ Rs=
+ 1.55902417e-03
+ Gd=
+ 2.04067990e-11

.Model Wmodel_Trace818::MIPI_DSI1_DATA3_N W MODELTYPE=RLGC N=1
+ Lo=
+ 3.32029740e-07
+ Co=
+ 1.03489020e-10
+ Ro=
+ 3.96831067e+00
+ Go=
+ 0.00000000e+00
+ Rs=
+ 1.55902417e-03
+ Gd=
+ 2.04067990e-11

.Model Wmodel_Trace821::MIPI_DSI1_DATA3_N W MODELTYPE=RLGC N=1
+ Lo=
+ 3.32029740e-07
+ Co=
+ 1.03489020e-10
+ Ro=
+ 3.96831067e+00
+ Go=
+ 0.00000000e+00
+ Rs=
+ 1.55902417e-03
+ Gd=
+ 2.04067990e-11

.Model Wmodel_Trace823::MIPI_DSI1_DATA3_N W MODELTYPE=RLGC N=1
+ Lo=
+ 3.32029740e-07
+ Co=
+ 1.03489020e-10
+ Ro=
+ 3.96831067e+00
+ Go=
+ 0.00000000e+00
+ Rs=
+ 1.55902417e-03
+ Gd=
+ 2.04067990e-11

.Model Wmodel_Trace832::MIPI_DSI1_DATA3_N W MODELTYPE=RLGC N=1
+ Lo=
+ 3.32029740e-07
+ Co=
+ 1.03489020e-10
+ Ro=
+ 3.96831067e+00
+ Go=
+ 0.00000000e+00
+ Rs=
+ 1.55902417e-03
+ Gd=
+ 2.04067990e-11

.Model Wmodel_Trace834#BP0::MIPI_DSI1_DATA3_N W MODELTYPE=RLGC N=2
+ Lo=
+ 3.30812626e-07
+ 4.12606258e-08 3.30812626e-07
+ Co=
+ 1.03787267e-10
+ -4.36948100e-12 1.03787267e-10
+ Ro=
+ 3.96831067e+00
+ 0.00000000e+00 3.96831067e+00
+ Go=
+ 0.00000000e+00
+ -0.00000000e+00 0.00000000e+00
+ Rs=
+ 1.55902417e-03
+ -0.00000000e+00 1.55902417e-03
+ Gd=
+ 2.03832867e-11
+ -1.60091039e-13 2.03832867e-11

.Model Wmodel_Trace834#BP0_Auto_2854::MIPI_DSI1_DATA3_N W MODELTYPE=RLGC N=1
+ Lo=
+ 3.32029740e-07
+ Co=
+ 1.03489020e-10
+ Ro=
+ 3.96831067e+00
+ Go=
+ 0.00000000e+00
+ Rs=
+ 1.55902417e-03
+ Gd=
+ 2.04067990e-11

.Model Wmodel_Trace854::MIPI_DSI1_DATA3_N W MODELTYPE=RLGC N=1
+ Lo=
+ 3.32029740e-07
+ Co=
+ 1.03489020e-10
+ Ro=
+ 3.96831067e+00
+ Go=
+ 0.00000000e+00
+ Rs=
+ 1.55902417e-03
+ Gd=
+ 2.04067990e-11

.Model Wmodel_Trace856::MIPI_DSI1_DATA3_N W MODELTYPE=RLGC N=1
+ Lo=
+ 3.32029740e-07
+ Co=
+ 1.03489020e-10
+ Ro=
+ 3.96831067e+00
+ Go=
+ 0.00000000e+00
+ Rs=
+ 1.55902417e-03
+ Gd=
+ 2.04067990e-11

.Model Wmodel_Trace856_Auto_2858::MIPI_DSI1_DATA3_N W MODELTYPE=RLGC N=2
+ Lo=
+ 3.30789178e-07
+ 4.15945532e-08 3.30789178e-07
+ Co=
+ 1.03794751e-10
+ -4.42535158e-12 1.03794751e-10
+ Ro=
+ 3.96831067e+00
+ 0.00000000e+00 3.96831067e+00
+ Go=
+ 0.00000000e+00
+ -0.00000000e+00 0.00000000e+00
+ Rs=
+ 1.55902417e-03
+ -0.00000000e+00 1.55902417e-03
+ Gd=
+ 2.03830730e-11
+ -1.65605629e-13 2.03830730e-11

.Model Wmodel_Trace856_Auto_2859::MIPI_DSI1_DATA3_N W MODELTYPE=RLGC N=1
+ Lo=
+ 3.32029740e-07
+ Co=
+ 1.03489020e-10
+ Ro=
+ 3.96831067e+00
+ Go=
+ 0.00000000e+00
+ Rs=
+ 1.55902417e-03
+ Gd=
+ 2.04067990e-11

.Model Wmodel_Trace858::MIPI_DSI1_DATA3_N W MODELTYPE=RLGC N=1
+ Lo=
+ 3.32029740e-07
+ Co=
+ 1.03489020e-10
+ Ro=
+ 3.96831067e+00
+ Go=
+ 0.00000000e+00
+ Rs=
+ 1.55902417e-03
+ Gd=
+ 2.04067990e-11

.Model Wmodel_Trace860::MIPI_DSI1_DATA3_N W MODELTYPE=RLGC N=1
+ Lo=
+ 3.32029740e-07
+ Co=
+ 1.03489020e-10
+ Ro=
+ 3.96831067e+00
+ Go=
+ 0.00000000e+00
+ Rs=
+ 1.55902417e-03
+ Gd=
+ 2.04067990e-11

.Model Wmodel_Trace860_Auto_2860::MIPI_DSI1_DATA3_N W MODELTYPE=RLGC N=2
+ Lo=
+ 3.30679971e-07
+ 4.31020423e-08 3.30679971e-07
+ Co=
+ 1.03830221e-10
+ -4.68137220e-12 1.03830221e-10
+ Ro=
+ 3.96831067e+00
+ 0.00000000e+00 3.96831067e+00
+ Go=
+ 0.00000000e+00
+ -0.00000000e+00 0.00000000e+00
+ Rs=
+ 1.55902417e-03
+ -0.00000000e+00 1.55902417e-03
+ Gd=
+ 2.03821898e-11
+ -1.91390818e-13 2.03821898e-11

.Model Wmodel_Trace864::MIPI_DSI1_DATA3_N W MODELTYPE=RLGC N=1
+ Lo=
+ 3.32029740e-07
+ Co=
+ 1.03489020e-10
+ Ro=
+ 3.96831067e+00
+ Go=
+ 0.00000000e+00
+ Rs=
+ 1.55902417e-03
+ Gd=
+ 2.04067990e-11

.Model Wmodel_Trace866::MIPI_DSI1_DATA3_N W MODELTYPE=RLGC N=2
+ Lo=
+ 3.30748904e-07
+ 4.21593990e-08 3.30748904e-07
+ Co=
+ 1.03807716e-10
+ -4.52055469e-12 1.03807716e-10
+ Ro=
+ 3.96831067e+00
+ 0.00000000e+00 3.96831067e+00
+ Go=
+ 0.00000000e+00
+ -0.00000000e+00 0.00000000e+00
+ Rs=
+ 1.55902417e-03
+ -0.00000000e+00 1.55902417e-03
+ Gd=
+ 2.03827260e-11
+ -1.75097034e-13 2.03827260e-11

.Model Wmodel_Trace867::MIPI_DSI1_DATA3_N W MODELTYPE=RLGC N=2
+ Lo=
+ 3.30748548e-07
+ 4.21643405e-08 3.30748548e-07
+ Co=
+ 1.03807831e-10
+ -4.52139143e-12 1.03807831e-10
+ Ro=
+ 3.96831067e+00
+ 0.00000000e+00 3.96831067e+00
+ Go=
+ 0.00000000e+00
+ -0.00000000e+00 0.00000000e+00
+ Rs=
+ 1.55902417e-03
+ -0.00000000e+00 1.55902417e-03
+ Gd=
+ 2.03827231e-11
+ -1.75180973e-13 2.03827231e-11

.Model Wmodel_Trace868::MIPI_DSI1_DATA3_N W MODELTYPE=RLGC N=2
+ Lo=
+ 3.30747262e-07
+ 4.21821942e-08 3.30747262e-07
+ Co=
+ 1.03808247e-10
+ -4.52441508e-12 1.03808247e-10
+ Ro=
+ 3.96831067e+00
+ 0.00000000e+00 3.96831067e+00
+ Go=
+ 0.00000000e+00
+ -0.00000000e+00 0.00000000e+00
+ Rs=
+ 1.55902417e-03
+ -0.00000000e+00 1.55902417e-03
+ Gd=
+ 2.03827124e-11
+ -1.75484369e-13 2.03827124e-11

.Model Wmodel_Trace869::MIPI_DSI1_DATA3_N W MODELTYPE=RLGC N=1
+ Lo=
+ 3.32029740e-07
+ Co=
+ 1.03489020e-10
+ Ro=
+ 3.96831067e+00
+ Go=
+ 0.00000000e+00
+ Rs=
+ 1.55902417e-03
+ Gd=
+ 2.04067990e-11

.Model Wmodel_Trace870::MIPI_DSI1_DATA3_N W MODELTYPE=RLGC N=2
+ Lo=
+ 3.31483690e-07
+ 2.93239108e-08 3.31483690e-07
+ Co=
+ 1.03596409e-10
+ -2.58292219e-12 1.03596409e-10
+ Ro=
+ 3.96831067e+00
+ 0.00000000e+00 3.96831067e+00
+ Go=
+ 0.00000000e+00
+ -0.00000000e+00 0.00000000e+00
+ Rs=
+ 1.55902417e-03
+ -0.00000000e+00 1.55902417e-03
+ Gd=
+ 2.03932636e-11
+ -1.20430265e-14 2.03932636e-11

.Model Wmodel_Trace877::MIPI_DSI1_DATA3_P W MODELTYPE=RLGC N=1
+ Lo=
+ 3.32029740e-07
+ Co=
+ 1.03489020e-10
+ Ro=
+ 3.96831067e+00
+ Go=
+ 0.00000000e+00
+ Rs=
+ 1.55902417e-03
+ Gd=
+ 2.04067990e-11

.Model Wmodel_Trace879::MIPI_DSI1_DATA3_P W MODELTYPE=RLGC N=1
+ Lo=
+ 3.32029740e-07
+ Co=
+ 1.03489020e-10
+ Ro=
+ 3.96831067e+00
+ Go=
+ 0.00000000e+00
+ Rs=
+ 1.55902417e-03
+ Gd=
+ 2.04067990e-11

.Model Wmodel_Trace883::MIPI_DSI1_DATA3_P W MODELTYPE=RLGC N=1
+ Lo=
+ 3.32029740e-07
+ Co=
+ 1.03489020e-10
+ Ro=
+ 3.96831067e+00
+ Go=
+ 0.00000000e+00
+ Rs=
+ 1.55902417e-03
+ Gd=
+ 2.04067990e-11

.Model Wmodel_Trace885::MIPI_DSI1_DATA3_P W MODELTYPE=RLGC N=2
+ Lo=
+ 3.30679690e-07
+ 4.31058267e-08 3.30679690e-07
+ Co=
+ 1.03830313e-10
+ -4.68202267e-12 1.03830313e-10
+ Ro=
+ 3.96831067e+00
+ 0.00000000e+00 3.96831067e+00
+ Go=
+ 0.00000000e+00
+ -0.00000000e+00 0.00000000e+00
+ Rs=
+ 1.55902417e-03
+ -0.00000000e+00 1.55902417e-03
+ Gd=
+ 2.03821877e-11
+ -1.91457368e-13 2.03821877e-11

.Model Wmodel_Trace885_Auto_2857::MIPI_DSI1_DATA3_P W MODELTYPE=RLGC N=4
+ Lo=
+ 3.30728126e-07
+ 4.09571895e-08 3.29428202e-07
+ 1.17817516e-08 4.22146727e-08 3.29371238e-07
+ 5.19915574e-09 1.19288700e-08 4.17935000e-08 3.30666620e-07
+ Co=
+ 1.03793797e-10
+ -4.33154624e-12 1.04120801e-10
+ -5.24170297e-13 -4.55310332e-12 1.04139602e-10
+ -2.31493269e-13 -5.29232890e-13 -4.47243276e-12 1.03812987e-10
+ Ro=
+ 3.96831067e+00
+ 0.00000000e+00 3.96831067e+00
+ 0.00000000e+00 0.00000000e+00 3.96831067e+00
+ 0.00000000e+00 0.00000000e+00 0.00000000e+00 3.96831067e+00
+ Go=
+ 0.00000000e+00
+ -0.00000000e+00 0.00000000e+00
+ -0.00000000e+00 -0.00000000e+00 0.00000000e+00
+ -0.00000000e+00 -0.00000000e+00 -0.00000000e+00 0.00000000e+00
+ Rs=
+ 1.55902417e-03
+ -0.00000000e+00 1.55902417e-03
+ -0.00000000e+00 -0.00000000e+00 1.55902417e-03
+ -0.00000000e+00 -0.00000000e+00 -0.00000000e+00 1.55902417e-03
+ Gd=
+ 2.03824480e-11
+ -1.65013405e-13 2.03592837e-11
+ -0.00000000e+00 -1.94123966e-13 2.03588027e-11
+ -0.00000000e+00 -0.00000000e+00 -1.79058895e-13 2.03819133e-11

.Model Wmodel_Trace894::MIPI_DSI1_DATA3_P W MODELTYPE=RLGC N=1
+ Lo=
+ 3.32029740e-07
+ Co=
+ 1.03489020e-10
+ Ro=
+ 3.96831067e+00
+ Go=
+ 0.00000000e+00
+ Rs=
+ 1.55902417e-03
+ Gd=
+ 2.04067990e-11

.Model Wmodel_Trace905::MIPI_DSI1_DATA3_P W MODELTYPE=RLGC N=1
+ Lo=
+ 3.32029740e-07
+ Co=
+ 1.03489020e-10
+ Ro=
+ 3.96831067e+00
+ Go=
+ 0.00000000e+00
+ Rs=
+ 1.55902417e-03
+ Gd=
+ 2.04067990e-11

.Model Wmodel_Trace907_Auto_2855::MIPI_DSI1_DATA3_P W MODELTYPE=RLGC N=1
+ Lo=
+ 3.32029740e-07
+ Co=
+ 1.03489020e-10
+ Ro=
+ 3.96831067e+00
+ Go=
+ 0.00000000e+00
+ Rs=
+ 1.55902417e-03
+ Gd=
+ 2.04067990e-11

.Model Wmodel_Trace916::MIPI_DSI1_DATA3_P W MODELTYPE=RLGC N=1
+ Lo=
+ 3.32029740e-07
+ Co=
+ 1.03489020e-10
+ Ro=
+ 3.96831067e+00
+ Go=
+ 0.00000000e+00
+ Rs=
+ 1.55902417e-03
+ Gd=
+ 2.04067990e-11

.Model Wmodel_Trace922::MIPI_DSI1_DATA3_P W MODELTYPE=RLGC N=1
+ Lo=
+ 3.32029740e-07
+ Co=
+ 1.03489020e-10
+ Ro=
+ 3.96831067e+00
+ Go=
+ 0.00000000e+00
+ Rs=
+ 1.55902417e-03
+ Gd=
+ 2.04067990e-11

.Model Wmodel_Trace926::MIPI_DSI1_DATA3_P W MODELTYPE=RLGC N=1
+ Lo=
+ 3.32029740e-07
+ Co=
+ 1.03489020e-10
+ Ro=
+ 3.96831067e+00
+ Go=
+ 0.00000000e+00
+ Rs=
+ 1.55902417e-03
+ Gd=
+ 2.04067990e-11

.Model Wmodel_Trace928::MIPI_DSI1_DATA3_P W MODELTYPE=RLGC N=1
+ Lo=
+ 3.32029740e-07
+ Co=
+ 1.03489020e-10
+ Ro=
+ 3.96831067e+00
+ Go=
+ 0.00000000e+00
+ Rs=
+ 1.55902417e-03
+ Gd=
+ 2.04067990e-11

.Model Wmodel_Trace928_Auto_2862::MIPI_DSI1_DATA3_P W MODELTYPE=RLGC N=1
+ Lo=
+ 3.32029740e-07
+ Co=
+ 1.03489020e-10
+ Ro=
+ 3.96831067e+00
+ Go=
+ 0.00000000e+00
+ Rs=
+ 1.55902417e-03
+ Gd=
+ 2.04067990e-11

.Model Wmodel_Trace932::MIPI_DSI1_DATA3_P W MODELTYPE=RLGC N=1
+ Lo=
+ 3.32029740e-07
+ Co=
+ 1.03489020e-10
+ Ro=
+ 3.96831067e+00
+ Go=
+ 0.00000000e+00
+ Rs=
+ 1.55902417e-03
+ Gd=
+ 2.04067990e-11

.Model Wmodel_Trace934::MIPI_DSI1_DATA3_P W MODELTYPE=RLGC N=1
+ Lo=
+ 3.32029740e-07
+ Co=
+ 1.03489020e-10
+ Ro=
+ 3.96831067e+00
+ Go=
+ 0.00000000e+00
+ Rs=
+ 1.55902417e-03
+ Gd=
+ 2.04067990e-11

.Model Wmodel_Trace934_Auto_2864::MIPI_DSI1_DATA3_P W MODELTYPE=RLGC N=1
+ Lo=
+ 3.32029740e-07
+ Co=
+ 1.03489020e-10
+ Ro=
+ 3.96831067e+00
+ Go=
+ 0.00000000e+00
+ Rs=
+ 1.55902417e-03
+ Gd=
+ 2.04067990e-11

.Model Wmodel_Trace935::MIPI_DSI1_DATA3_P W MODELTYPE=RLGC N=1
+ Lo=
+ 3.32029740e-07
+ Co=
+ 1.03489020e-10
+ Ro=
+ 3.96831067e+00
+ Go=
+ 0.00000000e+00
+ Rs=
+ 1.55902417e-03
+ Gd=
+ 2.04067990e-11

.Model Wmodel_Trace935_Auto_2866::MIPI_DSI1_DATA3_P W MODELTYPE=RLGC N=1
+ Lo=
+ 3.32029740e-07
+ Co=
+ 1.03489020e-10
+ Ro=
+ 3.96831067e+00
+ Go=
+ 0.00000000e+00
+ Rs=
+ 1.55902417e-03
+ Gd=
+ 2.04067990e-11

.Model Wmodel_Trace936::MIPI_DSI1_DATA3_P W MODELTYPE=RLGC N=1
+ Lo=
+ 3.32029740e-07
+ Co=
+ 1.03489020e-10
+ Ro=
+ 3.96831067e+00
+ Go=
+ 0.00000000e+00
+ Rs=
+ 1.55902417e-03
+ Gd=
+ 2.04067990e-11

.Model Wmodel_Trace937::MIPI_DSI1_DATA3_P W MODELTYPE=RLGC N=1
+ Lo=
+ 3.32029740e-07
+ Co=
+ 1.03489020e-10
+ Ro=
+ 3.96831067e+00
+ Go=
+ 0.00000000e+00
+ Rs=
+ 1.55902417e-03
+ Gd=
+ 2.04067990e-11

.Model Wmodel_Trace943_Auto_890::MIPI_DSI1_DATA3_P W MODELTYPE=RLGC N=2
+ Lo=
+ 3.30747262e-07
+ 4.21821942e-08 3.30747262e-07
+ Co=
+ 1.03808247e-10
+ -4.52441508e-12 1.03808247e-10
+ Ro=
+ 3.96831067e+00
+ 0.00000000e+00 3.96831067e+00
+ Go=
+ 0.00000000e+00
+ -0.00000000e+00 0.00000000e+00
+ Rs=
+ 1.55902417e-03
+ -0.00000000e+00 1.55902417e-03
+ Gd=
+ 2.03827124e-11
+ -1.75484369e-13 2.03827124e-11

.Model Wmodel_Trace943_Auto_909::MIPI_DSI1_DATA3_P W MODELTYPE=RLGC N=1
+ Lo=
+ 3.32029740e-07
+ Co=
+ 1.03489020e-10
+ Ro=
+ 3.96831067e+00
+ Go=
+ 0.00000000e+00
+ Rs=
+ 1.55902417e-03
+ Gd=
+ 2.04067990e-11

.Model Wmodel_Trace943_Auto_925::MIPI_DSI1_DATA3_P W MODELTYPE=RLGC N=1
+ Lo=
+ 3.32029740e-07
+ Co=
+ 1.03489020e-10
+ Ro=
+ 3.96831067e+00
+ Go=
+ 0.00000000e+00
+ Rs=
+ 1.55902417e-03
+ Gd=
+ 2.04067990e-11

.Model Wmodel_Trace943_Auto_935::MIPI_DSI1_DATA3_P W MODELTYPE=RLGC N=1
+ Lo=
+ 3.32029740e-07
+ Co=
+ 1.03489020e-10
+ Ro=
+ 3.96831067e+00
+ Go=
+ 0.00000000e+00
+ Rs=
+ 1.55902417e-03
+ Gd=
+ 2.04067990e-11

.Model Wmodel_Trace944::MIPI_DSI1_DATA3_P W MODELTYPE=RLGC N=1
+ Lo=
+ 3.32029740e-07
+ Co=
+ 1.03489020e-10
+ Ro=
+ 3.96831067e+00
+ Go=
+ 0.00000000e+00
+ Rs=
+ 1.55902417e-03
+ Gd=
+ 2.04067990e-11

.Model Wmodel_Trace945::MIPI_DSI1_DATA3_P W MODELTYPE=RLGC N=2
+ Lo=
+ 3.30853847e-07
+ 4.06641645e-08 3.30853847e-07
+ Co=
+ 1.03774227e-10
+ -4.27045073e-12 1.03774227e-10
+ Ro=
+ 3.96831067e+00
+ 0.00000000e+00 3.96831067e+00
+ Go=
+ 0.00000000e+00
+ -0.00000000e+00 0.00000000e+00
+ Rs=
+ 1.55902417e-03
+ -0.00000000e+00 1.55902417e-03
+ Gd=
+ 2.03836831e-11
+ -1.50420439e-13 2.03836831e-11

.Model Wmodel_Trace945_Auto_894::MIPI_DSI1_DATA3_P W MODELTYPE=RLGC N=1
+ Lo=
+ 3.32029740e-07
+ Co=
+ 1.03489020e-10
+ Ro=
+ 3.96831067e+00
+ Go=
+ 0.00000000e+00
+ Rs=
+ 1.55902417e-03
+ Gd=
+ 2.04067990e-11

.Model Wmodel_Trace946::MIPI_DSI1_DATA3_P W MODELTYPE=RLGC N=2
+ Lo=
+ 3.30748548e-07
+ 4.21643423e-08 3.30748548e-07
+ Co=
+ 1.03807831e-10
+ -4.52139172e-12 1.03807831e-10
+ Ro=
+ 3.96831067e+00
+ 0.00000000e+00 3.96831067e+00
+ Go=
+ 0.00000000e+00
+ -0.00000000e+00 0.00000000e+00
+ Rs=
+ 1.55902417e-03
+ -0.00000000e+00 1.55902417e-03
+ Gd=
+ 2.03827231e-11
+ -1.75181003e-13 2.03827231e-11

.Model Wmodel_Trace946_Auto_1824::MIPI_DSI1_DATA3_P W MODELTYPE=RLGC N=2
+ Lo=
+ 3.30715119e-07
+ 4.26250861e-08 3.30715119e-07
+ Co=
+ 1.03818696e-10
+ -4.59970040e-12 1.03818696e-10
+ Ro=
+ 3.96831067e+00
+ 0.00000000e+00 3.96831067e+00
+ Go=
+ 0.00000000e+00
+ -0.00000000e+00 0.00000000e+00
+ Rs=
+ 1.55902417e-03
+ -0.00000000e+00 1.55902417e-03
+ Gd=
+ 2.03824542e-11
+ -1.83075845e-13 2.03824542e-11

.Model Wmodel_Trace948::MIPI_DSI1_DATA3_P W MODELTYPE=RLGC N=1
+ Lo=
+ 3.32029740e-07
+ Co=
+ 1.03489020e-10
+ Ro=
+ 3.96831067e+00
+ Go=
+ 0.00000000e+00
+ Rs=
+ 1.55902417e-03
+ Gd=
+ 2.04067990e-11

.Model Wmodel_Trace950::MIPI_DSI1_DATA3_P W MODELTYPE=RLGC N=2
+ Lo=
+ 3.30740670e-07
+ 4.22735563e-08 3.30740670e-07
+ Co=
+ 1.03810383e-10
+ -4.53990158e-12 1.03810383e-10
+ Ro=
+ 3.96831067e+00
+ 0.00000000e+00 3.96831067e+00
+ Go=
+ 0.00000000e+00
+ -0.00000000e+00 0.00000000e+00
+ Rs=
+ 1.55902417e-03
+ -0.00000000e+00 1.55902417e-03
+ Gd=
+ 2.03826582e-11
+ -1.77040127e-13 2.03826582e-11

.Model Wmodel_Trace950_Auto_1784::MIPI_DSI1_DATA3_P W MODELTYPE=RLGC N=2
+ Lo=
+ 3.30748904e-07
+ 4.21593990e-08 3.30748904e-07
+ Co=
+ 1.03807716e-10
+ -4.52055469e-12 1.03807716e-10
+ Ro=
+ 3.96831067e+00
+ 0.00000000e+00 3.96831067e+00
+ Go=
+ 0.00000000e+00
+ -0.00000000e+00 0.00000000e+00
+ Rs=
+ 1.55902417e-03
+ -0.00000000e+00 1.55902417e-03
+ Gd=
+ 2.03827260e-11
+ -1.75097034e-13 2.03827260e-11

.Model Wmodel_Trace950_Auto_1792::MIPI_DSI1_DATA3_P W MODELTYPE=RLGC N=1
+ Lo=
+ 3.32029740e-07
+ Co=
+ 1.03489020e-10
+ Ro=
+ 3.96831067e+00
+ Go=
+ 0.00000000e+00
+ Rs=
+ 1.55902417e-03
+ Gd=
+ 2.04067990e-11

.Model Wmodel_Trace952::MIPI_DSI1_DATA3_P W MODELTYPE=RLGC N=1
+ Lo=
+ 3.32029740e-07
+ Co=
+ 1.03489020e-10
+ Ro=
+ 3.96831067e+00
+ Go=
+ 0.00000000e+00
+ Rs=
+ 1.55902417e-03
+ Gd=
+ 2.04067990e-11

.Model Wmodel_Trace954::MIPI_DSI1_DATA3_P W MODELTYPE=RLGC N=2
+ Lo=
+ 3.30739749e-07
+ 4.22863111e-08 3.30739749e-07
+ Co=
+ 1.03810682e-10
+ -4.54206543e-12 1.03810682e-10
+ Ro=
+ 3.96831067e+00
+ 0.00000000e+00 3.96831067e+00
+ Go=
+ 0.00000000e+00
+ -0.00000000e+00 0.00000000e+00
+ Rs=
+ 1.55902417e-03
+ -0.00000000e+00 1.55902417e-03
+ Gd=
+ 2.03826506e-11
+ -1.77257747e-13 2.03826506e-11

.Model Wmodel_Trace958::MIPI_DSI1_DATA3_P W MODELTYPE=RLGC N=1
+ Lo=
+ 3.32029740e-07
+ Co=
+ 1.03489020e-10
+ Ro=
+ 3.96831067e+00
+ Go=
+ 0.00000000e+00
+ Rs=
+ 1.55902417e-03
+ Gd=
+ 2.04067990e-11

.Model Wmodel_Trace960::MIPI_DSI1_DATA3_P W MODELTYPE=RLGC N=2
+ Lo=
+ 3.30748548e-07
+ 4.21643423e-08 3.30748548e-07
+ Co=
+ 1.03807831e-10
+ -4.52139172e-12 1.03807831e-10
+ Ro=
+ 3.96831067e+00
+ 0.00000000e+00 3.96831067e+00
+ Go=
+ 0.00000000e+00
+ -0.00000000e+00 0.00000000e+00
+ Rs=
+ 1.55902417e-03
+ -0.00000000e+00 1.55902417e-03
+ Gd=
+ 2.03827231e-11
+ -1.75181003e-13 2.03827231e-11

.Model Wmodel_Trace962::MIPI_DSI1_DATA3_P W MODELTYPE=RLGC N=1
+ Lo=
+ 3.32029740e-07
+ Co=
+ 1.03489020e-10
+ Ro=
+ 3.96831067e+00
+ Go=
+ 0.00000000e+00
+ Rs=
+ 1.55902417e-03
+ Gd=
+ 2.04067990e-11

.Model Wmodel_Trace964::MIPI_DSI1_DATA3_P W MODELTYPE=RLGC N=2
+ Lo=
+ 3.30740391e-07
+ 4.22774243e-08 3.30740391e-07
+ Co=
+ 1.03810473e-10
+ -4.54055774e-12 1.03810473e-10
+ Ro=
+ 3.96831067e+00
+ 0.00000000e+00 3.96831067e+00
+ Go=
+ 0.00000000e+00
+ -0.00000000e+00 0.00000000e+00
+ Rs=
+ 1.55902417e-03
+ -0.00000000e+00 1.55902417e-03
+ Gd=
+ 2.03826559e-11
+ -1.77106111e-13 2.03826559e-11

.Model Wmodel_Trace965#BP0::MIPI_DSI1_DATA3_P W MODELTYPE=RLGC N=2
+ Lo=
+ 3.31141023e-07
+ 3.61120642e-08 3.31141023e-07
+ Co=
+ 1.03687796e-10
+ -3.54765767e-12 1.03687796e-10
+ Ro=
+ 3.96831067e+00
+ 0.00000000e+00 3.96831067e+00
+ Go=
+ 0.00000000e+00
+ -0.00000000e+00 0.00000000e+00
+ Rs=
+ 1.55902417e-03
+ -0.00000000e+00 1.55902417e-03
+ Gd=
+ 2.03872091e-11
+ -8.43452651e-14 2.03872091e-11

.Model Wmodel_Trace966::MIPI_DSI1_DATA3_P W MODELTYPE=RLGC N=1
+ Lo=
+ 3.32029740e-07
+ Co=
+ 1.03489020e-10
+ Ro=
+ 3.96831067e+00
+ Go=
+ 0.00000000e+00
+ Rs=
+ 1.55902417e-03
+ Gd=
+ 2.04067990e-11

.Model Wmodel_Trace971::MIPI_DSI1_DATA2_N W MODELTYPE=RLGC N=1
+ Lo=
+ 3.58484574e-07
+ Co=
+ 9.37055974e-11
+ Ro=
+ 4.84133902e+00
+ Go=
+ 0.00000000e+00
+ Rs=
+ 1.72420198e-03
+ Gd=
+ 1.82370500e-11

.Model Wmodel_Trace973::MIPI_DSI1_DATA2_N W MODELTYPE=RLGC N=1
+ Lo=
+ 3.58484574e-07
+ Co=
+ 9.37055974e-11
+ Ro=
+ 4.84133902e+00
+ Go=
+ 0.00000000e+00
+ Rs=
+ 1.72420198e-03
+ Gd=
+ 1.82370500e-11

.Model Wmodel_Trace974_Auto_907::MIPI_DSI1_DATA2_N W MODELTYPE=RLGC N=1
+ Lo=
+ 3.32029740e-07
+ Co=
+ 1.03489020e-10
+ Ro=
+ 3.96831067e+00
+ Go=
+ 0.00000000e+00
+ Rs=
+ 1.55902417e-03
+ Gd=
+ 2.04067990e-11

.Model Wmodel_Trace974_Auto_923::MIPI_DSI1_DATA2_N W MODELTYPE=RLGC N=1
+ Lo=
+ 3.32029740e-07
+ Co=
+ 1.03489020e-10
+ Ro=
+ 3.96831067e+00
+ Go=
+ 0.00000000e+00
+ Rs=
+ 1.55902417e-03
+ Gd=
+ 2.04067990e-11

.Model Wmodel_Trace974_Auto_933::MIPI_DSI1_DATA2_N W MODELTYPE=RLGC N=1
+ Lo=
+ 3.32029740e-07
+ Co=
+ 1.03489020e-10
+ Ro=
+ 3.96831067e+00
+ Go=
+ 0.00000000e+00
+ Rs=
+ 1.55902417e-03
+ Gd=
+ 2.04067990e-11

.Model Wmodel_Trace975::MIPI_DSI1_DATA2_N W MODELTYPE=RLGC N=1
+ Lo=
+ 3.32029740e-07
+ Co=
+ 1.03489020e-10
+ Ro=
+ 3.96831067e+00
+ Go=
+ 0.00000000e+00
+ Rs=
+ 1.55902417e-03
+ Gd=
+ 2.04067990e-11

.Model Wmodel_Trace978::MIPI_DSI1_DATA2_N W MODELTYPE=RLGC N=1
+ Lo=
+ 3.32029740e-07
+ Co=
+ 1.03489020e-10
+ Ro=
+ 3.96831067e+00
+ Go=
+ 0.00000000e+00
+ Rs=
+ 1.55902417e-03
+ Gd=
+ 2.04067990e-11

.Model Wmodel_Trace979::MIPI_DSI1_DATA2_N W MODELTYPE=RLGC N=3
+ Lo=
+ 3.30536467e-07
+ 4.36968155e-08 3.29348102e-07
+ 1.22439114e-08 4.18548768e-08 3.30672143e-07
+ Co=
+ 1.03857943e-10
+ -4.79720114e-12 1.04165599e-10
+ -5.51023583e-13 -4.48076288e-12 1.03813293e-10
+ Ro=
+ 3.96831067e+00
+ 0.00000000e+00 3.96831067e+00
+ 0.00000000e+00 0.00000000e+00 3.96831067e+00
+ Go=
+ 0.00000000e+00
+ -0.00000000e+00 0.00000000e+00
+ -0.00000000e+00 -0.00000000e+00 0.00000000e+00
+ Rs=
+ 1.55902417e-03
+ -0.00000000e+00 1.55902417e-03
+ -0.00000000e+00 -0.00000000e+00 1.55902417e-03
+ Gd=
+ 2.03810138e-11
+ -2.11685665e-13 2.03588259e-11
+ -0.00000000e+00 -1.79752651e-13 2.03820020e-11

.Model Wmodel_Trace979_Auto_1816::MIPI_DSI1_DATA2_N W MODELTYPE=RLGC N=3
+ Lo=
+ 3.30536467e-07
+ 4.36968155e-08 3.29348102e-07
+ 1.22439114e-08 4.18548768e-08 3.30672143e-07
+ Co=
+ 1.03857943e-10
+ -4.79720114e-12 1.04165599e-10
+ -5.51023583e-13 -4.48076288e-12 1.03813293e-10
+ Ro=
+ 3.96831067e+00
+ 0.00000000e+00 3.96831067e+00
+ 0.00000000e+00 0.00000000e+00 3.96831067e+00
+ Go=
+ 0.00000000e+00
+ -0.00000000e+00 0.00000000e+00
+ -0.00000000e+00 -0.00000000e+00 0.00000000e+00
+ Rs=
+ 1.55902417e-03
+ -0.00000000e+00 1.55902417e-03
+ -0.00000000e+00 -0.00000000e+00 1.55902417e-03
+ Gd=
+ 2.03810138e-11
+ -2.11685665e-13 2.03588259e-11
+ -0.00000000e+00 -1.79752651e-13 2.03820020e-11

.Model Wmodel_Trace980::MIPI_DSI1_DATA2_N W MODELTYPE=RLGC N=1
+ Lo=
+ 3.32029740e-07
+ Co=
+ 1.03489020e-10
+ Ro=
+ 3.96831067e+00
+ Go=
+ 0.00000000e+00
+ Rs=
+ 1.55902417e-03
+ Gd=
+ 2.04067990e-11

.Model Wmodel_Trace983::MIPI_DSI1_DATA2_N W MODELTYPE=RLGC N=1
+ Lo=
+ 3.32029740e-07
+ Co=
+ 1.03489020e-10
+ Ro=
+ 3.96831067e+00
+ Go=
+ 0.00000000e+00
+ Rs=
+ 1.55902417e-03
+ Gd=
+ 2.04067990e-11

.Model Wmodel_Trace986::MIPI_DSI1_DATA2_N W MODELTYPE=RLGC N=1
+ Lo=
+ 3.32029740e-07
+ Co=
+ 1.03489020e-10
+ Ro=
+ 3.96831067e+00
+ Go=
+ 0.00000000e+00
+ Rs=
+ 1.55902417e-03
+ Gd=
+ 2.04067990e-11

.Model Wmodel_Trace988::MIPI_DSI1_DATA2_N W MODELTYPE=RLGC N=1
+ Lo=
+ 3.32029740e-07
+ Co=
+ 1.03489020e-10
+ Ro=
+ 3.96831067e+00
+ Go=
+ 0.00000000e+00
+ Rs=
+ 1.55902417e-03
+ Gd=
+ 2.04067990e-11

.Model Wmodel_Trace988_Auto_2871::MIPI_DSI1_DATA2_N W MODELTYPE=RLGC N=1
+ Lo=
+ 3.32029740e-07
+ Co=
+ 1.03489020e-10
+ Ro=
+ 3.96831067e+00
+ Go=
+ 0.00000000e+00
+ Rs=
+ 1.55902417e-03
+ Gd=
+ 2.04067990e-11

.Model Wmodel_Trace989::MIPI_DSI1_DATA2_N W MODELTYPE=RLGC N=1
+ Lo=
+ 3.32029740e-07
+ Co=
+ 1.03489020e-10
+ Ro=
+ 3.96831067e+00
+ Go=
+ 0.00000000e+00
+ Rs=
+ 1.55902417e-03
+ Gd=
+ 2.04067990e-11

.Model Wmodel_Trace989_Auto_2877::MIPI_DSI1_DATA2_N W MODELTYPE=RLGC N=1
+ Lo=
+ 3.32029740e-07
+ Co=
+ 1.03489020e-10
+ Ro=
+ 3.96831067e+00
+ Go=
+ 0.00000000e+00
+ Rs=
+ 1.55902417e-03
+ Gd=
+ 2.04067990e-11

.Model Wmodel_Trace999::MIPI_DSI1_DATA2_N W MODELTYPE=RLGC N=1
+ Lo=
+ 3.32029740e-07
+ Co=
+ 1.03489020e-10
+ Ro=
+ 3.96831067e+00
+ Go=
+ 0.00000000e+00
+ Rs=
+ 1.55902417e-03
+ Gd=
+ 2.04067990e-11
