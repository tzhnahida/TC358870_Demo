*Wmodel Definition*
*TraceModel Definition*

.Model Wmodel_Trace1348::MIPI_DSI1_DATA1_N W MODELTYPE=RLGC N=1
+ Lo=
+ 3.58484574e-07
+ Co=
+ 9.37055974e-11
+ Ro=
+ 4.84133902e+00
+ Go=
+ 0.00000000e+00
+ Rs=
+ 1.72420198e-03
+ Gd=
+ 1.82370500e-11

.Model Wmodel_Trace1350::MIPI_DSI1_DATA1_N W MODELTYPE=RLGC N=1
+ Lo=
+ 3.58484574e-07
+ Co=
+ 9.37055974e-11
+ Ro=
+ 4.84133902e+00
+ Go=
+ 0.00000000e+00
+ Rs=
+ 1.72420198e-03
+ Gd=
+ 1.82370500e-11

.Model Wmodel_Trace1351_Auto_1070::MIPI_DSI1_DATA1_N W MODELTYPE=RLGC N=1
+ Lo=
+ 3.32029740e-07
+ Co=
+ 1.03489020e-10
+ Ro=
+ 3.96831067e+00
+ Go=
+ 0.00000000e+00
+ Rs=
+ 1.55902417e-03
+ Gd=
+ 2.04067990e-11

.Model Wmodel_Trace1351_Auto_1078::MIPI_DSI1_DATA1_N W MODELTYPE=RLGC N=1
+ Lo=
+ 3.32029740e-07
+ Co=
+ 1.03489020e-10
+ Ro=
+ 3.96831067e+00
+ Go=
+ 0.00000000e+00
+ Rs=
+ 1.55902417e-03
+ Gd=
+ 2.04067990e-11

.Model Wmodel_Trace1353::MIPI_DSI1_DATA1_N W MODELTYPE=RLGC N=1
+ Lo=
+ 3.32029740e-07
+ Co=
+ 1.03489020e-10
+ Ro=
+ 3.96831067e+00
+ Go=
+ 0.00000000e+00
+ Rs=
+ 1.55902417e-03
+ Gd=
+ 2.04067990e-11

.Model Wmodel_Trace1355::MIPI_DSI1_DATA1_N W MODELTYPE=RLGC N=3
+ Lo=
+ 3.29511748e-07
+ 5.46615994e-08 3.28357979e-07
+ 1.39806269e-08 4.17151137e-08 3.30644549e-07
+ Co=
+ 1.04227008e-10
+ -6.87052906e-12 1.04531199e-10
+ -5.99462437e-13 -4.46327830e-12 1.03814752e-10
+ Ro=
+ 3.96831067e+00
+ 0.00000000e+00 3.96831067e+00
+ 0.00000000e+00 0.00000000e+00 3.96831067e+00
+ Go=
+ 0.00000000e+00
+ -0.00000000e+00 0.00000000e+00
+ -0.00000000e+00 -0.00000000e+00 0.00000000e+00
+ Rs=
+ 1.55902417e-03
+ -0.00000000e+00 1.55902417e-03
+ -0.00000000e+00 -0.00000000e+00 1.55902417e-03
+ Gd=
+ 2.03813601e-11
+ -4.48078073e-13 2.03597117e-11
+ -0.00000000e+00 -1.81351049e-13 2.03819024e-11

.Model Wmodel_Trace1356::MIPI_DSI1_DATA1_N W MODELTYPE=RLGC N=1
+ Lo=
+ 3.32029740e-07
+ Co=
+ 1.03489020e-10
+ Ro=
+ 3.96831067e+00
+ Go=
+ 0.00000000e+00
+ Rs=
+ 1.55902417e-03
+ Gd=
+ 2.04067990e-11

.Model Wmodel_Trace1357::MIPI_DSI1_DATA1_N W MODELTYPE=RLGC N=1
+ Lo=
+ 3.32029740e-07
+ Co=
+ 1.03489020e-10
+ Ro=
+ 3.96831067e+00
+ Go=
+ 0.00000000e+00
+ Rs=
+ 1.55902417e-03
+ Gd=
+ 2.04067990e-11

.Model Wmodel_Trace1357_Auto_721::MIPI_DSI1_DATA1_N W MODELTYPE=RLGC N=3
+ Lo=
+ 3.30439198e-07
+ 4.49027021e-08 3.29254904e-07
+ 1.24428937e-08 4.18342898e-08 3.30669702e-07
+ Co=
+ 1.03890022e-10
+ -5.00989972e-12 1.04197152e-10
+ -5.57071906e-13 -4.47784832e-12 1.03813306e-10
+ Ro=
+ 3.96831067e+00
+ 0.00000000e+00 3.96831067e+00
+ 0.00000000e+00 0.00000000e+00 3.96831067e+00
+ Go=
+ 0.00000000e+00
+ -0.00000000e+00 0.00000000e+00
+ -0.00000000e+00 -0.00000000e+00 0.00000000e+00
+ Rs=
+ 1.55902417e-03
+ -0.00000000e+00 1.55902417e-03
+ -0.00000000e+00 -0.00000000e+00 1.55902417e-03
+ Gd=
+ 2.03804751e-11
+ -2.34161414e-13 2.03583510e-11
+ -0.00000000e+00 -1.79821909e-13 2.03819933e-11

.Model Wmodel_Trace1359::MIPI_DSI1_DATA1_N W MODELTYPE=RLGC N=1
+ Lo=
+ 3.32029740e-07
+ Co=
+ 1.03489020e-10
+ Ro=
+ 3.96831067e+00
+ Go=
+ 0.00000000e+00
+ Rs=
+ 1.55902417e-03
+ Gd=
+ 2.04067990e-11

.Model Wmodel_Trace1360::MIPI_DSI1_DATA1_N W MODELTYPE=RLGC N=3
+ Lo=
+ 3.29807786e-07
+ 5.18253997e-08 3.28645831e-07
+ 1.35445950e-08 4.17373744e-08 3.30653137e-07
+ Co=
+ 1.04113875e-10
+ -6.30482862e-12 1.04418592e-10
+ -5.88208330e-13 -4.46521012e-12 1.03813997e-10
+ Ro=
+ 3.96831067e+00
+ 0.00000000e+00 3.96831067e+00
+ 0.00000000e+00 0.00000000e+00 3.96831067e+00
+ Go=
+ 0.00000000e+00
+ -0.00000000e+00 0.00000000e+00
+ -0.00000000e+00 -0.00000000e+00 0.00000000e+00
+ Rs=
+ 1.55902417e-03
+ -0.00000000e+00 1.55902417e-03
+ -0.00000000e+00 -0.00000000e+00 1.55902417e-03
+ Gd=
+ 2.03799668e-11
+ -3.80239707e-13 2.03581897e-11
+ -0.00000000e+00 -1.80666266e-13 2.03819350e-11

.Model Wmodel_Trace1363::MIPI_DSI1_DATA1_N W MODELTYPE=RLGC N=1
+ Lo=
+ 3.32029740e-07
+ Co=
+ 1.03489020e-10
+ Ro=
+ 3.96831067e+00
+ Go=
+ 0.00000000e+00
+ Rs=
+ 1.55902417e-03
+ Gd=
+ 2.04067990e-11

.Model Wmodel_Trace1374::MIPI_DSI1_DATA1_N W MODELTYPE=RLGC N=1
+ Lo=
+ 3.32029740e-07
+ Co=
+ 1.03489020e-10
+ Ro=
+ 3.96831067e+00
+ Go=
+ 0.00000000e+00
+ Rs=
+ 1.55902417e-03
+ Gd=
+ 2.04067990e-11

.Model Wmodel_Trace1376_Auto_43::MIPI_DSI1_DATA1_N W MODELTYPE=RLGC N=2
+ Lo=
+ 3.31051409e-07
+ 3.76162994e-08 3.31051409e-07
+ Co=
+ 1.03713897e-10
+ -3.77996421e-12 1.03713897e-10
+ Ro=
+ 3.96831067e+00
+ 0.00000000e+00 3.96831067e+00
+ Go=
+ 0.00000000e+00
+ -0.00000000e+00 0.00000000e+00
+ Rs=
+ 1.55902417e-03
+ -0.00000000e+00 1.55902417e-03
+ Gd=
+ 2.03859622e-11
+ -1.04649610e-13 2.03859622e-11

.Model Wmodel_Trace1376_Auto_44::MIPI_DSI1_DATA1_N W MODELTYPE=RLGC N=1
+ Lo=
+ 3.32029740e-07
+ Co=
+ 1.03489020e-10
+ Ro=
+ 3.96831067e+00
+ Go=
+ 0.00000000e+00
+ Rs=
+ 1.55902417e-03
+ Gd=
+ 2.04067990e-11

.Model Wmodel_Trace1380::MIPI_DSI1_DATA1_N W MODELTYPE=RLGC N=1
+ Lo=
+ 3.32029740e-07
+ Co=
+ 1.03489020e-10
+ Ro=
+ 3.96831067e+00
+ Go=
+ 0.00000000e+00
+ Rs=
+ 1.55902417e-03
+ Gd=
+ 2.04067990e-11

.Model Wmodel_Trace1382::MIPI_DSI1_DATA1_N W MODELTYPE=RLGC N=3
+ Lo=
+ 3.29617303e-07
+ 5.36752273e-08 3.28461580e-07
+ 1.38271948e-08 4.17094680e-08 3.30648588e-07
+ Co=
+ 1.04186141e-10
+ -6.67151051e-12 1.04490203e-10
+ -5.95557692e-13 -4.46165143e-12 1.03814169e-10
+ Ro=
+ 3.96831067e+00
+ 0.00000000e+00 3.96831067e+00
+ 0.00000000e+00 0.00000000e+00 3.96831067e+00
+ Go=
+ 0.00000000e+00
+ -0.00000000e+00 0.00000000e+00
+ -0.00000000e+00 -0.00000000e+00 0.00000000e+00
+ Rs=
+ 1.55902417e-03
+ -0.00000000e+00 1.55902417e-03
+ -0.00000000e+00 -0.00000000e+00 1.55902417e-03
+ Gd=
+ 2.03807524e-11
+ -4.23973008e-13 2.03590667e-11
+ -0.00000000e+00 -1.80880244e-13 2.03819219e-11

.Model Wmodel_Trace1383::MIPI_DSI1_DATA1_N W MODELTYPE=RLGC N=3
+ Lo=
+ 3.29807844e-07
+ 5.18248283e-08 3.28645887e-07
+ 1.35445070e-08 4.17373829e-08 3.30653139e-07
+ Co=
+ 1.04113853e-10
+ -6.30471668e-12 1.04418570e-10
+ -5.88206001e-13 -4.46521120e-12 1.03813997e-10
+ Ro=
+ 3.96831067e+00
+ 0.00000000e+00 3.96831067e+00
+ 0.00000000e+00 0.00000000e+00 3.96831067e+00
+ Go=
+ 0.00000000e+00
+ -0.00000000e+00 0.00000000e+00
+ -0.00000000e+00 -0.00000000e+00 0.00000000e+00
+ Rs=
+ 1.55902417e-03
+ -0.00000000e+00 1.55902417e-03
+ -0.00000000e+00 -0.00000000e+00 1.55902417e-03
+ Gd=
+ 2.03799666e-11
+ -3.80226495e-13 2.03581895e-11
+ -0.00000000e+00 -1.80666199e-13 2.03819350e-11

.Model Wmodel_Trace1386::MIPI_DSI1_DATA1_N W MODELTYPE=RLGC N=1
+ Lo=
+ 3.32029740e-07
+ Co=
+ 1.03489020e-10
+ Ro=
+ 3.96831067e+00
+ Go=
+ 0.00000000e+00
+ Rs=
+ 1.55902417e-03
+ Gd=
+ 2.04067990e-11

.Model Wmodel_Trace1397::MIPI_DSI1_DATA1_N W MODELTYPE=RLGC N=1
+ Lo=
+ 3.32029740e-07
+ Co=
+ 1.03489020e-10
+ Ro=
+ 3.96831067e+00
+ Go=
+ 0.00000000e+00
+ Rs=
+ 1.55902417e-03
+ Gd=
+ 2.04067990e-11

.Model Wmodel_Trace1399_Auto_28::MIPI_DSI1_DATA1_N W MODELTYPE=RLGC N=3
+ Lo=
+ 3.30605104e-07
+ 4.28177550e-08 3.29414390e-07
+ 1.20956864e-08 4.18611577e-08 3.30674544e-07
+ Co=
+ 1.03835745e-10
+ -4.64462333e-12 1.04143588e-10
+ -5.46432160e-13 -4.48141913e-12 1.03813082e-10
+ Ro=
+ 3.96831067e+00
+ 0.00000000e+00 3.96831067e+00
+ 0.00000000e+00 0.00000000e+00 3.96831067e+00
+ Go=
+ 0.00000000e+00
+ -0.00000000e+00 0.00000000e+00
+ -0.00000000e+00 -0.00000000e+00 0.00000000e+00
+ Rs=
+ 1.55902417e-03
+ -0.00000000e+00 1.55902417e-03
+ -0.00000000e+00 -0.00000000e+00 1.55902417e-03
+ Gd=
+ 2.03814731e-11
+ -1.95875076e-13 2.03592433e-11
+ -0.00000000e+00 -1.79555653e-13 2.03820139e-11

.Model Wmodel_Trace1399_Auto_29::MIPI_DSI1_DATA1_N W MODELTYPE=RLGC N=2
+ Lo=
+ 3.31054270e-07
+ 3.75695727e-08 3.31054270e-07
+ Co=
+ 1.03713051e-10
+ -3.77264973e-12 1.03713051e-10
+ Ro=
+ 3.96831067e+00
+ 0.00000000e+00 3.96831067e+00
+ Go=
+ 0.00000000e+00
+ -0.00000000e+00 0.00000000e+00
+ Rs=
+ 1.55902417e-03
+ -0.00000000e+00 1.55902417e-03
+ Gd=
+ 2.03859999e-11
+ -1.03995941e-13 2.03859999e-11

.Model Wmodel_Trace1401::MIPI_DSI1_DATA1_N W MODELTYPE=RLGC N=1
+ Lo=
+ 3.32029740e-07
+ Co=
+ 1.03489020e-10
+ Ro=
+ 3.96831067e+00
+ Go=
+ 0.00000000e+00
+ Rs=
+ 1.55902417e-03
+ Gd=
+ 2.04067990e-11

.Model Wmodel_Trace1405::MIPI_DSI1_DATA1_N W MODELTYPE=RLGC N=3
+ Lo=
+ 3.29889472e-07
+ 5.10029143e-08 3.28724782e-07
+ 1.34174505e-08 4.17495096e-08 3.30655144e-07
+ Co=
+ 1.04083513e-10
+ -6.14454157e-12 1.04388520e-10
+ -5.84817519e-13 -4.46676946e-12 1.03813919e-10
+ Ro=
+ 3.96831067e+00
+ 0.00000000e+00 3.96831067e+00
+ 0.00000000e+00 0.00000000e+00 3.96831067e+00
+ Go=
+ 0.00000000e+00
+ -0.00000000e+00 0.00000000e+00
+ -0.00000000e+00 -0.00000000e+00 0.00000000e+00
+ Rs=
+ 1.55902417e-03
+ -0.00000000e+00 1.55902417e-03
+ -0.00000000e+00 -0.00000000e+00 1.55902417e-03
+ Gd=
+ 2.03797569e-11
+ -3.61413480e-13 2.03579390e-11
+ -0.00000000e+00 -1.80569468e-13 2.03819412e-11

.Model Wmodel_Trace1406::MIPI_DSI1_DATA1_N W MODELTYPE=RLGC N=3
+ Lo=
+ 3.29937391e-07
+ 5.05116252e-08 3.28771077e-07
+ 1.33410511e-08 4.17566783e-08 3.30656337e-07
+ Co=
+ 1.04065884e-10
+ -6.04961287e-12 1.04371064e-10
+ -5.82754759e-13 -4.46769390e-12 1.03813872e-10
+ Ro=
+ 3.96831067e+00
+ 0.00000000e+00 3.96831067e+00
+ 0.00000000e+00 0.00000000e+00 3.96831067e+00
+ Go=
+ 0.00000000e+00
+ -0.00000000e+00 0.00000000e+00
+ -0.00000000e+00 -0.00000000e+00 0.00000000e+00
+ Rs=
+ 1.55902417e-03
+ -0.00000000e+00 1.55902417e-03
+ -0.00000000e+00 -0.00000000e+00 1.55902417e-03
+ Gd=
+ 2.03796703e-11
+ -3.50352541e-13 2.03578280e-11
+ -0.00000000e+00 -1.80511171e-13 2.03819450e-11

.Model Wmodel_Trace1407::MIPI_DSI1_DATA1_N W MODELTYPE=RLGC N=3
+ Lo=
+ 3.30570323e-07
+ 4.32665104e-08 3.29381141e-07
+ 1.21706640e-08 4.18531102e-08 3.30673684e-07
+ Co=
+ 1.03846951e-10
+ -4.72224815e-12 1.04154587e-10
+ -5.48763133e-13 -4.48026061e-12 1.03813075e-10
+ Ro=
+ 3.96831067e+00
+ 0.00000000e+00 3.96831067e+00
+ 0.00000000e+00 0.00000000e+00 3.96831067e+00
+ Go=
+ 0.00000000e+00
+ -0.00000000e+00 0.00000000e+00
+ -0.00000000e+00 -0.00000000e+00 0.00000000e+00
+ Rs=
+ 1.55902417e-03
+ -0.00000000e+00 1.55902417e-03
+ -0.00000000e+00 -0.00000000e+00 1.55902417e-03
+ Gd=
+ 2.03812321e-11
+ -2.03883344e-13 2.03590263e-11
+ -0.00000000e+00 -1.79573068e-13 2.03820108e-11

.Model Wmodel_Trace1409::MIPI_DSI1_DATA1_N W MODELTYPE=RLGC N=1
+ Lo=
+ 3.32029740e-07
+ Co=
+ 1.03489020e-10
+ Ro=
+ 3.96831067e+00
+ Go=
+ 0.00000000e+00
+ Rs=
+ 1.55902417e-03
+ Gd=
+ 2.04067990e-11

.Model Wmodel_Trace1409_Auto_465::MIPI_DSI1_DATA1_N W MODELTYPE=RLGC N=1
+ Lo=
+ 3.32029740e-07
+ Co=
+ 1.03489020e-10
+ Ro=
+ 3.96831067e+00
+ Go=
+ 0.00000000e+00
+ Rs=
+ 1.55902417e-03
+ Gd=
+ 2.04067990e-11

.Model Wmodel_Trace1411::MIPI_DSI1_DATA1_N W MODELTYPE=RLGC N=1
+ Lo=
+ 3.32029740e-07
+ Co=
+ 1.03489020e-10
+ Ro=
+ 3.96831067e+00
+ Go=
+ 0.00000000e+00
+ Rs=
+ 1.55902417e-03
+ Gd=
+ 2.04067990e-11

.Model Wmodel_Trace1413::MIPI_DSI1_DATA1_N W MODELTYPE=RLGC N=1
+ Lo=
+ 3.32029740e-07
+ Co=
+ 1.03489020e-10
+ Ro=
+ 3.96831067e+00
+ Go=
+ 0.00000000e+00
+ Rs=
+ 1.55902417e-03
+ Gd=
+ 2.04067990e-11

.Model Wmodel_Trace1413_Auto_165::MIPI_DSI1_DATA1_N W MODELTYPE=RLGC N=1
+ Lo=
+ 3.32029740e-07
+ Co=
+ 1.03489020e-10
+ Ro=
+ 3.96831067e+00
+ Go=
+ 0.00000000e+00
+ Rs=
+ 1.55902417e-03
+ Gd=
+ 2.04067990e-11

.Model Wmodel_Trace1434::MIPI_DSI1_DATA1_N W MODELTYPE=RLGC N=1
+ Lo=
+ 3.32029740e-07
+ Co=
+ 1.03489020e-10
+ Ro=
+ 3.96831067e+00
+ Go=
+ 0.00000000e+00
+ Rs=
+ 1.55902417e-03
+ Gd=
+ 2.04067990e-11

.Model Wmodel_Trace1440::MIPI_DSI1_DATA1_N W MODELTYPE=RLGC N=1
+ Lo=
+ 3.32029740e-07
+ Co=
+ 1.03489020e-10
+ Ro=
+ 3.96831067e+00
+ Go=
+ 0.00000000e+00
+ Rs=
+ 1.55902417e-03
+ Gd=
+ 2.04067990e-11

.Model Wmodel_Trace1442::MIPI_DSI1_DATA1_N W MODELTYPE=RLGC N=1
+ Lo=
+ 3.32029740e-07
+ Co=
+ 1.03489020e-10
+ Ro=
+ 3.96831067e+00
+ Go=
+ 0.00000000e+00
+ Rs=
+ 1.55902417e-03
+ Gd=
+ 2.04067990e-11

.Model Wmodel_Trace1445::MIPI_DSI1_DATA1_N W MODELTYPE=RLGC N=1
+ Lo=
+ 3.32029740e-07
+ Co=
+ 1.03489020e-10
+ Ro=
+ 3.96831067e+00
+ Go=
+ 0.00000000e+00
+ Rs=
+ 1.55902417e-03
+ Gd=
+ 2.04067990e-11

.Model Wmodel_Trace1447#BP0_Auto_2074::MIPI_DSI1_DATA1_N W MODELTYPE=RLGC N=2
+ Lo=
+ 3.30740685e-07
+ 4.22733596e-08 3.30740685e-07
+ Co=
+ 1.03810378e-10
+ -4.53986822e-12 1.03810378e-10
+ Ro=
+ 3.96831067e+00
+ 0.00000000e+00 3.96831067e+00
+ Go=
+ 0.00000000e+00
+ -0.00000000e+00 0.00000000e+00
+ Rs=
+ 1.55902417e-03
+ -0.00000000e+00 1.55902417e-03
+ Gd=
+ 2.03826583e-11
+ -1.77036772e-13 2.03826583e-11

.Model Wmodel_Trace1447#BP0_Auto_2075::MIPI_DSI1_DATA1_N W MODELTYPE=RLGC N=1
+ Lo=
+ 3.32029740e-07
+ Co=
+ 1.03489020e-10
+ Ro=
+ 3.96831067e+00
+ Go=
+ 0.00000000e+00
+ Rs=
+ 1.55902417e-03
+ Gd=
+ 2.04067990e-11

.Model Wmodel_Trace1449::MIPI_DSI1_DATA1_N W MODELTYPE=RLGC N=1
+ Lo=
+ 3.32029740e-07
+ Co=
+ 1.03489020e-10
+ Ro=
+ 3.96831067e+00
+ Go=
+ 0.00000000e+00
+ Rs=
+ 1.55902417e-03
+ Gd=
+ 2.04067990e-11

.Model Wmodel_Trace1449_Auto_2041::MIPI_DSI1_DATA1_N W MODELTYPE=RLGC N=4
+ Lo=
+ 3.30731790e-07
+ 4.08848603e-08 3.29447399e-07
+ 1.16130572e-08 4.14101819e-08 3.28217837e-07
+ 5.75770467e-09 1.39624744e-08 5.53262110e-08 3.29421011e-07
+ Co=
+ 1.03792262e-10
+ -4.32034461e-12 1.04105876e-10
+ -5.11784737e-13 -4.42362454e-12 1.04564919e-10
+ -2.43511192e-13 -5.85895143e-13 -7.01010666e-12 1.04257870e-10
+ Ro=
+ 3.96831067e+00
+ 0.00000000e+00 3.96831067e+00
+ 0.00000000e+00 0.00000000e+00 3.96831067e+00
+ 0.00000000e+00 0.00000000e+00 0.00000000e+00 3.96831067e+00
+ Go=
+ 0.00000000e+00
+ -0.00000000e+00 0.00000000e+00
+ -0.00000000e+00 -0.00000000e+00 0.00000000e+00
+ -0.00000000e+00 -0.00000000e+00 -0.00000000e+00 0.00000000e+00
+ Rs=
+ 1.55902417e-03
+ -0.00000000e+00 1.55902417e-03
+ -0.00000000e+00 -0.00000000e+00 1.55902417e-03
+ -0.00000000e+00 -0.00000000e+00 -0.00000000e+00 1.55902417e-03
+ Gd=
+ 2.03824939e-11
+ -1.63796361e-13 2.03595663e-11
+ -0.00000000e+00 -1.84933736e-13 2.03596725e-11
+ -0.00000000e+00 -0.00000000e+00 -4.65673465e-13 2.03817322e-11

.Model Wmodel_Trace1451::MIPI_DSI1_DATA1_N W MODELTYPE=RLGC N=1
+ Lo=
+ 3.32029740e-07
+ Co=
+ 1.03489020e-10
+ Ro=
+ 3.96831067e+00
+ Go=
+ 0.00000000e+00
+ Rs=
+ 1.55902417e-03
+ Gd=
+ 2.04067990e-11

.Model Wmodel_Trace1451_Auto_2031::MIPI_DSI1_DATA1_N W MODELTYPE=RLGC N=1
+ Lo=
+ 3.32029740e-07
+ Co=
+ 1.03489020e-10
+ Ro=
+ 3.96831067e+00
+ Go=
+ 0.00000000e+00
+ Rs=
+ 1.55902417e-03
+ Gd=
+ 2.04067990e-11

.Model Wmodel_Trace1451_Auto_2053::MIPI_DSI1_DATA1_N W MODELTYPE=RLGC N=1
+ Lo=
+ 3.32029740e-07
+ Co=
+ 1.03489020e-10
+ Ro=
+ 3.96831067e+00
+ Go=
+ 0.00000000e+00
+ Rs=
+ 1.55902417e-03
+ Gd=
+ 2.04067990e-11

.Model Wmodel_Trace1452::MIPI_DSI1_DATA1_N W MODELTYPE=RLGC N=1
+ Lo=
+ 3.32029740e-07
+ Co=
+ 1.03489020e-10
+ Ro=
+ 3.96831067e+00
+ Go=
+ 0.00000000e+00
+ Rs=
+ 1.55902417e-03
+ Gd=
+ 2.04067990e-11

.Model Wmodel_Trace1453::MIPI_DSI1_DATA1_N W MODELTYPE=RLGC N=2
+ Lo=
+ 3.30748548e-07
+ 4.21643405e-08 3.30748548e-07
+ Co=
+ 1.03807831e-10
+ -4.52139143e-12 1.03807831e-10
+ Ro=
+ 3.96831067e+00
+ 0.00000000e+00 3.96831067e+00
+ Go=
+ 0.00000000e+00
+ -0.00000000e+00 0.00000000e+00
+ Rs=
+ 1.55902417e-03
+ -0.00000000e+00 1.55902417e-03
+ Gd=
+ 2.03827231e-11
+ -1.75180973e-13 2.03827231e-11

.Model Wmodel_Trace1453_Auto_2061::MIPI_DSI1_DATA1_N W MODELTYPE=RLGC N=2
+ Lo=
+ 3.31006394e-07
+ 3.83409681e-08 3.31006394e-07
+ Co=
+ 1.03727316e-10
+ -3.89420171e-12 1.03727316e-10
+ Ro=
+ 3.96831067e+00
+ 0.00000000e+00 3.96831067e+00
+ Go=
+ 0.00000000e+00
+ -0.00000000e+00 0.00000000e+00
+ Rs=
+ 1.55902417e-03
+ -0.00000000e+00 1.55902417e-03
+ Gd=
+ 2.03853867e-11
+ -1.14974238e-13 2.03853867e-11

.Model Wmodel_Trace1453_Auto_2064::MIPI_DSI1_DATA1_N W MODELTYPE=RLGC N=1
+ Lo=
+ 3.32029740e-07
+ Co=
+ 1.03489020e-10
+ Ro=
+ 3.96831067e+00
+ Go=
+ 0.00000000e+00
+ Rs=
+ 1.55902417e-03
+ Gd=
+ 2.04067990e-11

.Model Wmodel_Trace1454::MIPI_DSI1_DATA1_N W MODELTYPE=RLGC N=1
+ Lo=
+ 3.32029740e-07
+ Co=
+ 1.03489020e-10
+ Ro=
+ 3.96831067e+00
+ Go=
+ 0.00000000e+00
+ Rs=
+ 1.55902417e-03
+ Gd=
+ 2.04067990e-11

.Model Wmodel_Trace1558::MIPI_DSI1_DATA1_P W MODELTYPE=RLGC N=1
+ Lo=
+ 3.58484574e-07
+ Co=
+ 9.37055974e-11
+ Ro=
+ 4.84133902e+00
+ Go=
+ 0.00000000e+00
+ Rs=
+ 1.72420198e-03
+ Gd=
+ 1.82370500e-11

.Model Wmodel_Trace1559_Auto_1068::MIPI_DSI1_DATA1_P W MODELTYPE=RLGC N=1
+ Lo=
+ 3.32029740e-07
+ Co=
+ 1.03489020e-10
+ Ro=
+ 3.96831067e+00
+ Go=
+ 0.00000000e+00
+ Rs=
+ 1.55902417e-03
+ Gd=
+ 2.04067990e-11

.Model Wmodel_Trace1559_Auto_1076::MIPI_DSI1_DATA1_P W MODELTYPE=RLGC N=1
+ Lo=
+ 3.32029740e-07
+ Co=
+ 1.03489020e-10
+ Ro=
+ 3.96831067e+00
+ Go=
+ 0.00000000e+00
+ Rs=
+ 1.55902417e-03
+ Gd=
+ 2.04067990e-11

.Model Wmodel_Trace1561::MIPI_DSI1_DATA1_P W MODELTYPE=RLGC N=1
+ Lo=
+ 3.32029740e-07
+ Co=
+ 1.03489020e-10
+ Ro=
+ 3.96831067e+00
+ Go=
+ 0.00000000e+00
+ Rs=
+ 1.55902417e-03
+ Gd=
+ 2.04067990e-11

.Model Wmodel_Trace1563::MIPI_DSI1_DATA1_P W MODELTYPE=RLGC N=1
+ Lo=
+ 3.32029740e-07
+ Co=
+ 1.03489020e-10
+ Ro=
+ 3.96831067e+00
+ Go=
+ 0.00000000e+00
+ Rs=
+ 1.55902417e-03
+ Gd=
+ 2.04067990e-11

.Model Wmodel_Trace1563_Auto_703::MIPI_DSI1_DATA1_P W MODELTYPE=RLGC N=4
+ Lo=
+ 3.30626976e-07
+ 4.16351572e-08 3.28095683e-07
+ 1.40768914e-08 5.57957336e-08 3.28094494e-07
+ 5.82956711e-09 1.40808517e-08 4.16527744e-08 3.30625630e-07
+ Co=
+ 1.03815644e-10
+ -4.45465600e-12 1.04601012e-10
+ -5.87533924e-13 -7.13356071e-12 1.04601416e-10
+ -2.56102480e-13 -5.87660399e-13 -4.45765366e-12 1.03816061e-10
+ Ro=
+ 3.96831067e+00
+ 0.00000000e+00 3.96831067e+00
+ 0.00000000e+00 0.00000000e+00 3.96831067e+00
+ 0.00000000e+00 0.00000000e+00 0.00000000e+00 3.96831067e+00
+ Go=
+ 0.00000000e+00
+ -0.00000000e+00 0.00000000e+00
+ -0.00000000e+00 -0.00000000e+00 0.00000000e+00
+ -0.00000000e+00 -0.00000000e+00 -0.00000000e+00 0.00000000e+00
+ Rs=
+ 1.55902417e-03
+ -0.00000000e+00 1.55902417e-03
+ -0.00000000e+00 -0.00000000e+00 1.55902417e-03
+ -0.00000000e+00 -0.00000000e+00 -0.00000000e+00 1.55902417e-03
+ Gd=
+ 2.03817460e-11
+ -1.81559349e-13 2.03602127e-11
+ -0.00000000e+00 -4.89739438e-13 2.03602034e-11
+ -0.00000000e+00 -0.00000000e+00 -1.81862067e-13 2.03817352e-11

.Model Wmodel_Trace1565::MIPI_DSI1_DATA1_P W MODELTYPE=RLGC N=1
+ Lo=
+ 3.32029740e-07
+ Co=
+ 1.03489020e-10
+ Ro=
+ 3.96831067e+00
+ Go=
+ 0.00000000e+00
+ Rs=
+ 1.55902417e-03
+ Gd=
+ 2.04067990e-11

.Model Wmodel_Trace1567::MIPI_DSI1_DATA1_P W MODELTYPE=RLGC N=4
+ Lo=
+ 3.30622209e-07
+ 4.17667582e-08 3.28234558e-07
+ 1.39021157e-08 5.44623017e-08 3.28242213e-07
+ 5.78313177e-09 1.38772872e-08 4.16538580e-08 3.30630828e-07
+ Co=
+ 1.03818106e-10
+ -4.47600401e-12 1.04545525e-10
+ -5.83446481e-13 -6.85952703e-12 1.04542927e-10
+ -2.54189014e-13 -5.82648703e-13 -4.45678451e-12 1.03815431e-10
+ Ro=
+ 3.96831067e+00
+ 0.00000000e+00 3.96831067e+00
+ 0.00000000e+00 0.00000000e+00 3.96831067e+00
+ 0.00000000e+00 0.00000000e+00 0.00000000e+00 3.96831067e+00
+ Go=
+ 0.00000000e+00
+ -0.00000000e+00 0.00000000e+00
+ -0.00000000e+00 -0.00000000e+00 0.00000000e+00
+ -0.00000000e+00 -0.00000000e+00 -0.00000000e+00 0.00000000e+00
+ Rs=
+ 1.55902417e-03
+ -0.00000000e+00 1.55902417e-03
+ -0.00000000e+00 -0.00000000e+00 1.55902417e-03
+ -0.00000000e+00 -0.00000000e+00 -0.00000000e+00 1.55902417e-03
+ Gd=
+ 2.03816896e-11
+ -1.83291919e-13 2.03590212e-11
+ -0.00000000e+00 -4.56099387e-13 2.03590806e-11
+ -0.00000000e+00 -0.00000000e+00 -1.81349711e-13 2.03817588e-11

.Model Wmodel_Trace1571::MIPI_DSI1_DATA1_P W MODELTYPE=RLGC N=1
+ Lo=
+ 3.32029740e-07
+ Co=
+ 1.03489020e-10
+ Ro=
+ 3.96831067e+00
+ Go=
+ 0.00000000e+00
+ Rs=
+ 1.55902417e-03
+ Gd=
+ 2.04067990e-11

.Model Wmodel_Trace1573::MIPI_DSI1_DATA1_P W MODELTYPE=RLGC N=1
+ Lo=
+ 3.32029740e-07
+ Co=
+ 1.03489020e-10
+ Ro=
+ 3.96831067e+00
+ Go=
+ 0.00000000e+00
+ Rs=
+ 1.55902417e-03
+ Gd=
+ 2.04067990e-11

.Model Wmodel_Trace1573_Auto_40::MIPI_DSI1_DATA1_P W MODELTYPE=RLGC N=1
+ Lo=
+ 3.32029740e-07
+ Co=
+ 1.03489020e-10
+ Ro=
+ 3.96831067e+00
+ Go=
+ 0.00000000e+00
+ Rs=
+ 1.55902417e-03
+ Gd=
+ 2.04067990e-11

.Model Wmodel_Trace1575::MIPI_DSI1_DATA1_P W MODELTYPE=RLGC N=1
+ Lo=
+ 3.32029740e-07
+ Co=
+ 1.03489020e-10
+ Ro=
+ 3.96831067e+00
+ Go=
+ 0.00000000e+00
+ Rs=
+ 1.55902417e-03
+ Gd=
+ 2.04067990e-11

.Model Wmodel_Trace1582::MIPI_DSI1_DATA1_P W MODELTYPE=RLGC N=1
+ Lo=
+ 3.32029740e-07
+ Co=
+ 1.03489020e-10
+ Ro=
+ 3.96831067e+00
+ Go=
+ 0.00000000e+00
+ Rs=
+ 1.55902417e-03
+ Gd=
+ 2.04067990e-11

.Model Wmodel_Trace1584_Auto_22::MIPI_DSI1_DATA1_P W MODELTYPE=RLGC N=1
+ Lo=
+ 3.32029740e-07
+ Co=
+ 1.03489020e-10
+ Ro=
+ 3.96831067e+00
+ Go=
+ 0.00000000e+00
+ Rs=
+ 1.55902417e-03
+ Gd=
+ 2.04067990e-11

.Model Wmodel_Trace1584_Auto_27::MIPI_DSI1_DATA1_P W MODELTYPE=RLGC N=1
+ Lo=
+ 3.32029740e-07
+ Co=
+ 1.03489020e-10
+ Ro=
+ 3.96831067e+00
+ Go=
+ 0.00000000e+00
+ Rs=
+ 1.55902417e-03
+ Gd=
+ 2.04067990e-11

.Model Wmodel_Trace1588::MIPI_DSI1_DATA1_P W MODELTYPE=RLGC N=1
+ Lo=
+ 3.32029740e-07
+ Co=
+ 1.03489020e-10
+ Ro=
+ 3.96831067e+00
+ Go=
+ 0.00000000e+00
+ Rs=
+ 1.55902417e-03
+ Gd=
+ 2.04067990e-11

.Model Wmodel_Trace1590::MIPI_DSI1_DATA1_P W MODELTYPE=RLGC N=4
+ Lo=
+ 3.30654453e-07
+ 4.13288140e-08 3.28232414e-07
+ 1.38535475e-08 5.47719771e-08 3.28210861e-07
+ 5.76962000e-09 1.39245282e-08 4.16493387e-08 3.30630143e-07
+ Co=
+ 1.03807945e-10
+ -4.40182270e-12 1.04548500e-10
+ -5.81768316e-13 -6.92221986e-12 1.04555789e-10
+ -2.53991474e-13 -5.84052371e-13 -4.45619682e-12 1.03815456e-10
+ Ro=
+ 3.96831067e+00
+ 0.00000000e+00 3.96831067e+00
+ 0.00000000e+00 0.00000000e+00 3.96831067e+00
+ 0.00000000e+00 0.00000000e+00 0.00000000e+00 3.96831067e+00
+ Go=
+ 0.00000000e+00
+ -0.00000000e+00 0.00000000e+00
+ -0.00000000e+00 -0.00000000e+00 0.00000000e+00
+ -0.00000000e+00 -0.00000000e+00 -0.00000000e+00 0.00000000e+00
+ Rs=
+ 1.55902417e-03
+ -0.00000000e+00 1.55902417e-03
+ -0.00000000e+00 -0.00000000e+00 1.55902417e-03
+ -0.00000000e+00 -0.00000000e+00 -0.00000000e+00 1.55902417e-03
+ Gd=
+ 2.03819577e-11
+ -1.75913591e-13 2.03594928e-11
+ -0.00000000e+00 -4.63609680e-13 2.03593202e-11
+ -0.00000000e+00 -0.00000000e+00 -1.81383162e-13 2.03817569e-11

.Model Wmodel_Trace1594::MIPI_DSI1_DATA1_P W MODELTYPE=RLGC N=1
+ Lo=
+ 3.32029740e-07
+ Co=
+ 1.03489020e-10
+ Ro=
+ 3.96831067e+00
+ Go=
+ 0.00000000e+00
+ Rs=
+ 1.55902417e-03
+ Gd=
+ 2.04067990e-11

.Model Wmodel_Trace1596_Auto_23::MIPI_DSI1_DATA1_P W MODELTYPE=RLGC N=1
+ Lo=
+ 3.32029740e-07
+ Co=
+ 1.03489020e-10
+ Ro=
+ 3.96831067e+00
+ Go=
+ 0.00000000e+00
+ Rs=
+ 1.55902417e-03
+ Gd=
+ 2.04067990e-11

.Model Wmodel_Trace1596_Auto_24::MIPI_DSI1_DATA1_P W MODELTYPE=RLGC N=1
+ Lo=
+ 3.32029740e-07
+ Co=
+ 1.03489020e-10
+ Ro=
+ 3.96831067e+00
+ Go=
+ 0.00000000e+00
+ Rs=
+ 1.55902417e-03
+ Gd=
+ 2.04067990e-11

.Model Wmodel_Trace1605::MIPI_DSI1_DATA1_P W MODELTYPE=RLGC N=1
+ Lo=
+ 3.32029740e-07
+ Co=
+ 1.03489020e-10
+ Ro=
+ 3.96831067e+00
+ Go=
+ 0.00000000e+00
+ Rs=
+ 1.55902417e-03
+ Gd=
+ 2.04067990e-11

.Model Wmodel_Trace1607_Auto_30::MIPI_DSI1_DATA1_P W MODELTYPE=RLGC N=1
+ Lo=
+ 3.32029740e-07
+ Co=
+ 1.03489020e-10
+ Ro=
+ 3.96831067e+00
+ Go=
+ 0.00000000e+00
+ Rs=
+ 1.55902417e-03
+ Gd=
+ 2.04067990e-11

.Model Wmodel_Trace1607_Auto_31::MIPI_DSI1_DATA1_P W MODELTYPE=RLGC N=1
+ Lo=
+ 3.32029740e-07
+ Co=
+ 1.03489020e-10
+ Ro=
+ 3.96831067e+00
+ Go=
+ 0.00000000e+00
+ Rs=
+ 1.55902417e-03
+ Gd=
+ 2.04067990e-11

.Model Wmodel_Trace1607_Auto_37::MIPI_DSI1_DATA1_P W MODELTYPE=RLGC N=8
+ Lo=
+ 3.30658873e-07
+ 4.18342871e-08 3.29393773e-07
+ 1.18111459e-08 4.15697049e-08 3.29323992e-07
+ 5.15075674e-09 1.17068666e-08 4.15257191e-08 3.29323593e-07
+ 2.84466275e-09 5.09473416e-09 1.16742842e-08 4.14220686e-08 3.29364272e-07
+ 1.79642958e-09 2.80224610e-09 5.05562896e-09 1.15672569e-08 4.09140016e-08 3.29298634e-07
+ 1.24971712e-09 1.78990837e-09 2.82104527e-09 5.10903572e-09 1.17576830e-08 4.24988381e-08 3.29325687e-07
+ 9.25832773e-10 1.24973874e-09 1.80583086e-09 2.85002935e-09 5.16461211e-09 1.19689421e-08 4.18206457e-08 3.30656778e-07
+ Co=
+ 1.03814457e-10
+ -4.47996230e-12 1.04127856e-10
+ -5.24067133e-13 -4.44677451e-12 1.04132714e-10
+ -2.21826146e-13 -5.09157912e-13 -4.44184901e-12 1.04130571e-10
+ -1.23352954e-13 -2.13652649e-13 -5.07745348e-13 -4.42444372e-12 1.04116940e-10
+ -7.84504460e-14 -1.17708446e-13 -2.11817556e-13 -5.03691816e-13 -4.33872687e-12 1.04141007e-10
+ -5.48899323e-14 -7.54198356e-14 -1.18049395e-13 -2.13451477e-13 -5.10680184e-13 -4.60586055e-12 1.04149850e-10
+ -4.26382948e-14 -5.50377877e-14 -7.88041912e-14 -1.23475576e-13 -2.22787576e-13 -5.29251915e-13 -4.47809760e-12 1.03814527e-10
+ Ro=
+ 3.96831067e+00
+ 0.00000000e+00 3.96831067e+00
+ 0.00000000e+00 0.00000000e+00 3.96831067e+00
+ 0.00000000e+00 0.00000000e+00 0.00000000e+00 3.96831067e+00
+ 0.00000000e+00 0.00000000e+00 0.00000000e+00 0.00000000e+00 3.96831067e+00
+ 0.00000000e+00 0.00000000e+00 0.00000000e+00 0.00000000e+00 0.00000000e+00 3.96831067e+00
+ 0.00000000e+00 0.00000000e+00 0.00000000e+00 0.00000000e+00 0.00000000e+00 0.00000000e+00 3.96831067e+00
+ 0.00000000e+00 0.00000000e+00 0.00000000e+00 0.00000000e+00 0.00000000e+00 0.00000000e+00 0.00000000e+00 3.96831067e+00
+ Go=
+ 0.00000000e+00
+ -0.00000000e+00 0.00000000e+00
+ -0.00000000e+00 -0.00000000e+00 0.00000000e+00
+ -0.00000000e+00 -0.00000000e+00 -0.00000000e+00 0.00000000e+00
+ -0.00000000e+00 -0.00000000e+00 -0.00000000e+00 -0.00000000e+00 0.00000000e+00
+ -0.00000000e+00 -0.00000000e+00 -0.00000000e+00 -0.00000000e+00 -0.00000000e+00 0.00000000e+00
+ -0.00000000e+00 -0.00000000e+00 -0.00000000e+00 -0.00000000e+00 -0.00000000e+00 -0.00000000e+00 0.00000000e+00
+ -0.00000000e+00 -0.00000000e+00 -0.00000000e+00 -0.00000000e+00 -0.00000000e+00 -0.00000000e+00 -0.00000000e+00 0.00000000e+00
+ Rs=
+ 1.55902417e-03
+ -0.00000000e+00 1.55902417e-03
+ -0.00000000e+00 -0.00000000e+00 1.55902417e-03
+ -0.00000000e+00 -0.00000000e+00 -0.00000000e+00 1.55902417e-03
+ -0.00000000e+00 -0.00000000e+00 -0.00000000e+00 -0.00000000e+00 1.55902417e-03
+ -0.00000000e+00 -0.00000000e+00 -0.00000000e+00 -0.00000000e+00 -0.00000000e+00 1.55902417e-03
+ -0.00000000e+00 -0.00000000e+00 -0.00000000e+00 -0.00000000e+00 -0.00000000e+00 -0.00000000e+00 1.55902417e-03
+ -0.00000000e+00 -0.00000000e+00 -0.00000000e+00 -0.00000000e+00 -0.00000000e+00 -0.00000000e+00 -0.00000000e+00 1.55902417e-03
+ Gd=
+ 2.03818215e-11
+ -1.79833582e-13 2.03589286e-11
+ -0.00000000e+00 -1.84218654e-13 2.03583100e-11
+ -0.00000000e+00 -0.00000000e+00 -1.84149540e-13 2.03582870e-11
+ -0.00000000e+00 -0.00000000e+00 -0.00000000e+00 -1.82324076e-13 2.03586249e-11
+ -0.00000000e+00 -0.00000000e+00 -0.00000000e+00 -0.00000000e+00 -1.74061035e-13 2.03581644e-11
+ -0.00000000e+00 -0.00000000e+00 -0.00000000e+00 -0.00000000e+00 -0.00000000e+00 -2.00287253e-13 2.03584344e-11
+ -0.00000000e+00 -0.00000000e+00 -0.00000000e+00 -0.00000000e+00 -0.00000000e+00 -0.00000000e+00 -1.79925322e-13 2.03818113e-11

.Model Wmodel_Trace1611::MIPI_DSI1_DATA1_P W MODELTYPE=RLGC N=1
+ Lo=
+ 3.32029740e-07
+ Co=
+ 1.03489020e-10
+ Ro=
+ 3.96831067e+00
+ Go=
+ 0.00000000e+00
+ Rs=
+ 1.55902417e-03
+ Gd=
+ 2.04067990e-11

.Model Wmodel_Trace1613::MIPI_DSI1_DATA1_P W MODELTYPE=RLGC N=4
+ Lo=
+ 3.30631079e-07
+ 4.16552741e-08 3.28251175e-07
+ 1.38659144e-08 5.43848566e-08 3.28251175e-07
+ 5.77346869e-09 1.38659144e-08 4.16552741e-08 3.30631079e-07
+ Co=
+ 1.03815421e-10
+ -4.45694869e-12 1.04539558e-10
+ -5.82434746e-13 -6.84358847e-12 1.04539558e-10
+ -2.53893575e-13 -5.82434747e-13 -4.45694869e-12 1.03815421e-10
+ Ro=
+ 3.96831067e+00
+ 0.00000000e+00 3.96831067e+00
+ 0.00000000e+00 0.00000000e+00 3.96831067e+00
+ 0.00000000e+00 0.00000000e+00 0.00000000e+00 3.96831067e+00
+ Go=
+ 0.00000000e+00
+ -0.00000000e+00 0.00000000e+00
+ -0.00000000e+00 -0.00000000e+00 0.00000000e+00
+ -0.00000000e+00 -0.00000000e+00 -0.00000000e+00 0.00000000e+00
+ Rs=
+ 1.55902417e-03
+ -0.00000000e+00 1.55902417e-03
+ -0.00000000e+00 -0.00000000e+00 1.55902417e-03
+ -0.00000000e+00 -0.00000000e+00 -0.00000000e+00 1.55902417e-03
+ Gd=
+ 2.03817596e-11
+ -1.81339997e-13 2.03590229e-11
+ -0.00000000e+00 -4.54113706e-13 2.03590229e-11
+ -0.00000000e+00 -0.00000000e+00 -1.81339997e-13 2.03817596e-11

.Model Wmodel_Trace1615::MIPI_DSI1_DATA1_P W MODELTYPE=RLGC N=1
+ Lo=
+ 3.32029740e-07
+ Co=
+ 1.03489020e-10
+ Ro=
+ 3.96831067e+00
+ Go=
+ 0.00000000e+00
+ Rs=
+ 1.55902417e-03
+ Gd=
+ 2.04067990e-11

.Model Wmodel_Trace1617::MIPI_DSI1_DATA1_P W MODELTYPE=RLGC N=1
+ Lo=
+ 3.32029740e-07
+ Co=
+ 1.03489020e-10
+ Ro=
+ 3.96831067e+00
+ Go=
+ 0.00000000e+00
+ Rs=
+ 1.55902417e-03
+ Gd=
+ 2.04067990e-11

.Model Wmodel_Trace1617_Auto_458::MIPI_DSI1_DATA1_P W MODELTYPE=RLGC N=4
+ Lo=
+ 3.30629583e-07
+ 4.18222816e-08 3.28543957e-07
+ 1.34461900e-08 5.14613359e-08 3.28521002e-07
+ 5.68905506e-09 1.35158378e-08 4.21561294e-08 3.30604038e-07
+ Co=
+ 1.03817980e-10
+ -4.48325565e-12 1.04426357e-10
+ -5.71698006e-13 -6.25920798e-12 1.04434143e-10
+ -2.50091409e-13 -5.73962782e-13 -4.54027030e-12 1.03825976e-10
+ Ro=
+ 3.96831067e+00
+ 0.00000000e+00 3.96831067e+00
+ 0.00000000e+00 0.00000000e+00 3.96831067e+00
+ 0.00000000e+00 0.00000000e+00 0.00000000e+00 3.96831067e+00
+ Go=
+ 0.00000000e+00
+ -0.00000000e+00 0.00000000e+00
+ -0.00000000e+00 -0.00000000e+00 0.00000000e+00
+ -0.00000000e+00 -0.00000000e+00 -0.00000000e+00 0.00000000e+00
+ Rs=
+ 1.55902417e-03
+ -0.00000000e+00 1.55902417e-03
+ -0.00000000e+00 -0.00000000e+00 1.55902417e-03
+ -0.00000000e+00 -0.00000000e+00 -0.00000000e+00 1.55902417e-03
+ Gd=
+ 2.03817107e-11
+ -1.83072719e-13 2.03573838e-11
+ -0.00000000e+00 -3.84082050e-13 2.03572114e-11
+ -0.00000000e+00 -0.00000000e+00 -1.88859132e-13 2.03815110e-11

.Model Wmodel_Trace1617_Auto_469::MIPI_DSI1_DATA1_P W MODELTYPE=RLGC N=2
+ Lo=
+ 3.30748548e-07
+ 4.21643423e-08 3.30748548e-07
+ Co=
+ 1.03807831e-10
+ -4.52139172e-12 1.03807831e-10
+ Ro=
+ 3.96831067e+00
+ 0.00000000e+00 3.96831067e+00
+ Go=
+ 0.00000000e+00
+ -0.00000000e+00 0.00000000e+00
+ Rs=
+ 1.55902417e-03
+ -0.00000000e+00 1.55902417e-03
+ Gd=
+ 2.03827231e-11
+ -1.75181003e-13 2.03827231e-11

.Model Wmodel_Trace1619::MIPI_DSI1_DATA1_P W MODELTYPE=RLGC N=1
+ Lo=
+ 3.32029740e-07
+ Co=
+ 1.03489020e-10
+ Ro=
+ 3.96831067e+00
+ Go=
+ 0.00000000e+00
+ Rs=
+ 1.55902417e-03
+ Gd=
+ 2.04067990e-11

.Model Wmodel_Trace1621::MIPI_DSI1_DATA1_P W MODELTYPE=RLGC N=2
+ Lo=
+ 3.30740391e-07
+ 4.22774243e-08 3.30740391e-07
+ Co=
+ 1.03810473e-10
+ -4.54055774e-12 1.03810473e-10
+ Ro=
+ 3.96831067e+00
+ 0.00000000e+00 3.96831067e+00
+ Go=
+ 0.00000000e+00
+ -0.00000000e+00 0.00000000e+00
+ Rs=
+ 1.55902417e-03
+ -0.00000000e+00 1.55902417e-03
+ Gd=
+ 2.03826559e-11
+ -1.77106111e-13 2.03826559e-11

.Model Wmodel_Trace1625::MIPI_DSI1_DATA1_P W MODELTYPE=RLGC N=1
+ Lo=
+ 3.32029740e-07
+ Co=
+ 1.03489020e-10
+ Ro=
+ 3.96831067e+00
+ Go=
+ 0.00000000e+00
+ Rs=
+ 1.55902417e-03
+ Gd=
+ 2.04067990e-11

.Model Wmodel_Trace1636::MIPI_DSI1_DATA1_P W MODELTYPE=RLGC N=1
+ Lo=
+ 3.32029740e-07
+ Co=
+ 1.03489020e-10
+ Ro=
+ 3.96831067e+00
+ Go=
+ 0.00000000e+00
+ Rs=
+ 1.55902417e-03
+ Gd=
+ 2.04067990e-11

.Model Wmodel_Trace1647::MIPI_DSI1_DATA1_P W MODELTYPE=RLGC N=1
+ Lo=
+ 3.32029740e-07
+ Co=
+ 1.03489020e-10
+ Ro=
+ 3.96831067e+00
+ Go=
+ 0.00000000e+00
+ Rs=
+ 1.55902417e-03
+ Gd=
+ 2.04067990e-11

.Model Wmodel_Trace1649::MIPI_DSI1_DATA1_P W MODELTYPE=RLGC N=1
+ Lo=
+ 3.32029740e-07
+ Co=
+ 1.03489020e-10
+ Ro=
+ 3.96831067e+00
+ Go=
+ 0.00000000e+00
+ Rs=
+ 1.55902417e-03
+ Gd=
+ 2.04067990e-11

.Model Wmodel_Trace1658#BP0::MIPI_DSI1_DATA1_P W MODELTYPE=RLGC N=1
+ Lo=
+ 3.32029740e-07
+ Co=
+ 1.03489020e-10
+ Ro=
+ 3.96831067e+00
+ Go=
+ 0.00000000e+00
+ Rs=
+ 1.55902417e-03
+ Gd=
+ 2.04067990e-11

.Model Wmodel_Trace1660::MIPI_DSI1_DATA1_P W MODELTYPE=RLGC N=1
+ Lo=
+ 3.32029740e-07
+ Co=
+ 1.03489020e-10
+ Ro=
+ 3.96831067e+00
+ Go=
+ 0.00000000e+00
+ Rs=
+ 1.55902417e-03
+ Gd=
+ 2.04067990e-11

.Model Wmodel_Trace1660_Auto_54::MIPI_DSI1_DATA1_P W MODELTYPE=RLGC N=4
+ Lo=
+ 3.30731045e-07
+ 4.09245204e-08 3.29442901e-07
+ 1.17482518e-08 4.20497136e-08 3.29379008e-07
+ 5.19280479e-09 1.19125199e-08 4.18617688e-08 3.30662097e-07
+ Co=
+ 1.03792997e-10
+ -4.32600522e-12 1.04116082e-10
+ -5.23093480e-13 -4.52479750e-12 1.04137172e-10
+ -2.31213560e-13 -5.28749605e-13 -4.48393300e-12 1.03814520e-10
+ Ro=
+ 3.96831067e+00
+ 0.00000000e+00 3.96831067e+00
+ 0.00000000e+00 0.00000000e+00 3.96831067e+00
+ 0.00000000e+00 0.00000000e+00 0.00000000e+00 3.96831067e+00
+ Go=
+ 0.00000000e+00
+ -0.00000000e+00 0.00000000e+00
+ -0.00000000e+00 -0.00000000e+00 0.00000000e+00
+ -0.00000000e+00 -0.00000000e+00 -0.00000000e+00 0.00000000e+00
+ Rs=
+ 1.55902417e-03
+ -0.00000000e+00 1.55902417e-03
+ -0.00000000e+00 -0.00000000e+00 1.55902417e-03
+ -0.00000000e+00 -0.00000000e+00 -0.00000000e+00 1.55902417e-03
+ Gd=
+ 2.03824731e-11
+ -1.64416963e-13 2.03593935e-11
+ -0.00000000e+00 -1.91239428e-13 2.03588550e-11
+ -0.00000000e+00 -0.00000000e+00 -1.80166297e-13 2.03818748e-11

.Model Wmodel_Trace1664::MIPI_DSI1_DATA1_P W MODELTYPE=RLGC N=1
+ Lo=
+ 3.32029740e-07
+ Co=
+ 1.03489020e-10
+ Ro=
+ 3.96831067e+00
+ Go=
+ 0.00000000e+00
+ Rs=
+ 1.55902417e-03
+ Gd=
+ 2.04067990e-11

.Model Wmodel_Trace1666#BP0::MIPI_DSI1_DATA1_P W MODELTYPE=RLGC N=2
+ Lo=
+ 3.30906868e-07
+ 3.98782800e-08 3.30906868e-07
+ Co=
+ 1.03757677e-10
+ -4.14147894e-12 1.03757677e-10
+ Ro=
+ 3.96831067e+00
+ 0.00000000e+00 3.96831067e+00
+ Go=
+ 0.00000000e+00
+ -0.00000000e+00 0.00000000e+00
+ Rs=
+ 1.55902417e-03
+ -0.00000000e+00 1.55902417e-03
+ Gd=
+ 2.03842326e-11
+ -1.38032384e-13 2.03842326e-11

.Model Wmodel_Trace1666#BP0_Auto_139::MIPI_DSI1_DATA1_P W MODELTYPE=RLGC N=1
+ Lo=
+ 3.32029740e-07
+ Co=
+ 1.03489020e-10
+ Ro=
+ 3.96831067e+00
+ Go=
+ 0.00000000e+00
+ Rs=
+ 1.55902417e-03
+ Gd=
+ 2.04067990e-11

.Model Wmodel_Trace1666::MIPI_DSI1_DATA1_P W MODELTYPE=RLGC N=2
+ Lo=
+ 3.30800836e-07
+ 4.14290146e-08 3.30800836e-07
+ Co=
+ 1.03791024e-10
+ -4.39761636e-12 1.03791024e-10
+ Ro=
+ 3.96831067e+00
+ 0.00000000e+00 3.96831067e+00
+ Go=
+ 0.00000000e+00
+ -0.00000000e+00 0.00000000e+00
+ Rs=
+ 1.55902417e-03
+ -0.00000000e+00 1.55902417e-03
+ Gd=
+ 2.03831782e-11
+ -1.62862873e-13 2.03831782e-11

.Model Wmodel_Trace1666_Auto_162::MIPI_DSI1_DATA1_P W MODELTYPE=RLGC N=2
+ Lo=
+ 3.30767226e-07
+ 4.19037621e-08 3.30767226e-07
+ Co=
+ 1.03801800e-10
+ -4.47735960e-12 1.03801800e-10
+ Ro=
+ 3.96831067e+00
+ 0.00000000e+00 3.96831067e+00
+ Go=
+ 0.00000000e+00
+ -0.00000000e+00 0.00000000e+00
+ Rs=
+ 1.55902417e-03
+ -0.00000000e+00 1.55902417e-03
+ Gd=
+ 2.03828808e-11
+ -1.70776059e-13 2.03828808e-11

.Model Wmodel_Trace1666_Auto_163::MIPI_DSI1_DATA1_P W MODELTYPE=RLGC N=1
+ Lo=
+ 3.32029740e-07
+ Co=
+ 1.03489020e-10
+ Ro=
+ 3.96831067e+00
+ Go=
+ 0.00000000e+00
+ Rs=
+ 1.55902417e-03
+ Gd=
+ 2.04067990e-11

.Model Wmodel_Trace1666_Auto_167::MIPI_DSI1_DATA1_P W MODELTYPE=RLGC N=1
+ Lo=
+ 3.32029740e-07
+ Co=
+ 1.03489020e-10
+ Ro=
+ 3.96831067e+00
+ Go=
+ 0.00000000e+00
+ Rs=
+ 1.55902417e-03
+ Gd=
+ 2.04067990e-11

.Model Wmodel_Trace1672::MIPI_DSI1_DATA1_P W MODELTYPE=RLGC N=1
+ Lo=
+ 3.32029740e-07
+ Co=
+ 1.03489020e-10
+ Ro=
+ 3.96831067e+00
+ Go=
+ 0.00000000e+00
+ Rs=
+ 1.55902417e-03
+ Gd=
+ 2.04067990e-11

.Model Wmodel_Trace1673::MIPI_DSI1_DATA1_P W MODELTYPE=RLGC N=1
+ Lo=
+ 3.32029740e-07
+ Co=
+ 1.03489020e-10
+ Ro=
+ 3.96831067e+00
+ Go=
+ 0.00000000e+00
+ Rs=
+ 1.55902417e-03
+ Gd=
+ 2.04067990e-11

.Model Wmodel_Trace1673_Auto_2065::MIPI_DSI1_DATA1_P W MODELTYPE=RLGC N=2
+ Lo=
+ 3.30714878e-07
+ 4.26283926e-08 3.30714878e-07
+ Co=
+ 1.03818775e-10
+ -4.60026447e-12 1.03818775e-10
+ Ro=
+ 3.96831067e+00
+ 0.00000000e+00 3.96831067e+00
+ Go=
+ 0.00000000e+00
+ -0.00000000e+00 0.00000000e+00
+ Rs=
+ 1.55902417e-03
+ -0.00000000e+00 1.55902417e-03
+ Gd=
+ 2.03824523e-11
+ -1.83132992e-13 2.03824523e-11

.Model Wmodel_Trace1673_Auto_2066::MIPI_DSI1_DATA1_P W MODELTYPE=RLGC N=1
+ Lo=
+ 3.32029740e-07
+ Co=
+ 1.03489020e-10
+ Ro=
+ 3.96831067e+00
+ Go=
+ 0.00000000e+00
+ Rs=
+ 1.55902417e-03
+ Gd=
+ 2.04067990e-11

.Model Wmodel_Trace1675::MIPI_DSI1_DATA1_P W MODELTYPE=RLGC N=1
+ Lo=
+ 3.32029740e-07
+ Co=
+ 1.03489020e-10
+ Ro=
+ 3.96831067e+00
+ Go=
+ 0.00000000e+00
+ Rs=
+ 1.55902417e-03
+ Gd=
+ 2.04067990e-11

.Model Wmodel_Trace1677::MIPI_DSI1_DATA1_P W MODELTYPE=RLGC N=1
+ Lo=
+ 3.32029740e-07
+ Co=
+ 1.03489020e-10
+ Ro=
+ 3.96831067e+00
+ Go=
+ 0.00000000e+00
+ Rs=
+ 1.55902417e-03
+ Gd=
+ 2.04067990e-11

.Model Wmodel_Trace1677_Auto_2092::MIPI_DSI1_DATA1_P W MODELTYPE=RLGC N=1
+ Lo=
+ 3.32029740e-07
+ Co=
+ 1.03489020e-10
+ Ro=
+ 3.96831067e+00
+ Go=
+ 0.00000000e+00
+ Rs=
+ 1.55902417e-03
+ Gd=
+ 2.04067990e-11

.Model Wmodel_Trace1679::MIPI_DSI1_DATA1_P W MODELTYPE=RLGC N=1
+ Lo=
+ 3.32029740e-07
+ Co=
+ 1.03489020e-10
+ Ro=
+ 3.96831067e+00
+ Go=
+ 0.00000000e+00
+ Rs=
+ 1.55902417e-03
+ Gd=
+ 2.04067990e-11

.Model Wmodel_Trace1681_Auto_2033::MIPI_DSI1_DATA1_P W MODELTYPE=RLGC N=1
+ Lo=
+ 3.32029740e-07
+ Co=
+ 1.03489020e-10
+ Ro=
+ 3.96831067e+00
+ Go=
+ 0.00000000e+00
+ Rs=
+ 1.55902417e-03
+ Gd=
+ 2.04067990e-11

.Model Wmodel_Trace1681_Auto_2055::MIPI_DSI1_DATA1_P W MODELTYPE=RLGC N=4
+ Lo=
+ 3.30641687e-07
+ 4.17250541e-08 3.28669578e-07
+ 1.32410545e-08 5.02855166e-08 3.28661774e-07
+ 5.61468699e-09 1.32644262e-08 4.18391905e-08 3.30633035e-07
+ Co=
+ 1.03815097e-10
+ -4.46582593e-12 1.04380484e-10
+ -5.66409138e-13 -6.02947340e-12 1.04383115e-10
+ -2.47472574e-13 -5.67176058e-13 -4.48524277e-12 1.03817797e-10
+ Ro=
+ 3.96831067e+00
+ 0.00000000e+00 3.96831067e+00
+ 0.00000000e+00 0.00000000e+00 3.96831067e+00
+ 0.00000000e+00 0.00000000e+00 0.00000000e+00 3.96831067e+00
+ Go=
+ 0.00000000e+00
+ -0.00000000e+00 0.00000000e+00
+ -0.00000000e+00 -0.00000000e+00 0.00000000e+00
+ -0.00000000e+00 -0.00000000e+00 -0.00000000e+00 0.00000000e+00
+ Rs=
+ 1.55902417e-03
+ -0.00000000e+00 1.55902417e-03
+ -0.00000000e+00 -0.00000000e+00 1.55902417e-03
+ -0.00000000e+00 -0.00000000e+00 -0.00000000e+00 1.55902417e-03
+ Gd=
+ 2.03817934e-11
+ -1.80932383e-13 2.03571279e-11
+ -0.00000000e+00 -3.56949109e-13 2.03570672e-11
+ -0.00000000e+00 -0.00000000e+00 -1.82893170e-13 2.03817236e-11

.Model Wmodel_Trace1681_Auto_2056::MIPI_DSI1_DATA1_P W MODELTYPE=RLGC N=1
+ Lo=
+ 3.32029740e-07
+ Co=
+ 1.03489020e-10
+ Ro=
+ 3.96831067e+00
+ Go=
+ 0.00000000e+00
+ Rs=
+ 1.55902417e-03
+ Gd=
+ 2.04067990e-11

.Model Wmodel_Trace1681_Auto_2062::MIPI_DSI1_DATA1_P W MODELTYPE=RLGC N=1
+ Lo=
+ 3.32029740e-07
+ Co=
+ 1.03489020e-10
+ Ro=
+ 3.96831067e+00
+ Go=
+ 0.00000000e+00
+ Rs=
+ 1.55902417e-03
+ Gd=
+ 2.04067990e-11

.Model Wmodel_Trace1682::MIPI_DSI1_DATA1_P W MODELTYPE=RLGC N=1
+ Lo=
+ 3.32029740e-07
+ Co=
+ 1.03489020e-10
+ Ro=
+ 3.96831067e+00
+ Go=
+ 0.00000000e+00
+ Rs=
+ 1.55902417e-03
+ Gd=
+ 2.04067990e-11

.Model Wmodel_Trace1683::MIPI_DSI1_DATA1_P W MODELTYPE=RLGC N=1
+ Lo=
+ 3.32029740e-07
+ Co=
+ 1.03489020e-10
+ Ro=
+ 3.96831067e+00
+ Go=
+ 0.00000000e+00
+ Rs=
+ 1.55902417e-03
+ Gd=
+ 2.04067990e-11

.Model Wmodel_Trace1684::MIPI_DSI1_DATA1_P W MODELTYPE=RLGC N=1
+ Lo=
+ 3.32029740e-07
+ Co=
+ 1.03489020e-10
+ Ro=
+ 3.96831067e+00
+ Go=
+ 0.00000000e+00
+ Rs=
+ 1.55902417e-03
+ Gd=
+ 2.04067990e-11

.Model Wmodel_Trace1686::MIPI_DSI1_DATA1_P W MODELTYPE=RLGC N=1
+ Lo=
+ 3.32029740e-07
+ Co=
+ 1.03489020e-10
+ Ro=
+ 3.96831067e+00
+ Go=
+ 0.00000000e+00
+ Rs=
+ 1.55902417e-03
+ Gd=
+ 2.04067990e-11

.Model Wmodel_Trace1686_Auto_1951::MIPI_DSI1_DATA1_P W MODELTYPE=RLGC N=1
+ Lo=
+ 3.32029740e-07
+ Co=
+ 1.03489020e-10
+ Ro=
+ 3.96831067e+00
+ Go=
+ 0.00000000e+00
+ Rs=
+ 1.55902417e-03
+ Gd=
+ 2.04067990e-11

.Model Wmodel_Trace1689::MIPI_DSI1_DATA0_N W MODELTYPE=RLGC N=1
+ Lo=
+ 3.58484574e-07
+ Co=
+ 9.37055974e-11
+ Ro=
+ 4.84133902e+00
+ Go=
+ 0.00000000e+00
+ Rs=
+ 1.72420198e-03
+ Gd=
+ 1.82370500e-11

.Model Wmodel_Trace1691::MIPI_DSI1_DATA0_N W MODELTYPE=RLGC N=1
+ Lo=
+ 3.58484574e-07
+ Co=
+ 9.37055974e-11
+ Ro=
+ 4.84133902e+00
+ Go=
+ 0.00000000e+00
+ Rs=
+ 1.72420198e-03
+ Gd=
+ 1.82370500e-11

.Model Wmodel_Trace1693::MIPI_DSI1_DATA0_N W MODELTYPE=RLGC N=1
+ Lo=
+ 3.32029740e-07
+ Co=
+ 1.03489020e-10
+ Ro=
+ 3.96831067e+00
+ Go=
+ 0.00000000e+00
+ Rs=
+ 1.55902417e-03
+ Gd=
+ 2.04067990e-11

.Model Wmodel_Trace1694_Auto_1066::MIPI_DSI1_DATA0_N W MODELTYPE=RLGC N=5
+ Lo=
+ 3.30376314e-07
+ 4.55885919e-08 3.29366430e-07
+ 1.17249315e-08 3.78030858e-08 3.29284445e-07
+ 5.32683491e-09 1.16624054e-08 4.54655748e-08 3.29102432e-07
+ 2.95086658e-09 5.14016933e-09 1.24741475e-08 4.18106046e-08 3.30650450e-07
+ Co=
+ 1.03909634e-10
+ -5.13401837e-12 1.04144261e-10
+ -5.18909590e-13 -3.82711064e-12 1.04153570e-10
+ -2.24071019e-13 -5.05918703e-13 -5.12779380e-12 1.04226888e-10
+ -1.30889061e-13 -2.23501317e-13 -5.46243658e-13 -4.47750771e-12 1.03815211e-10
+ Ro=
+ 3.96831067e+00
+ 0.00000000e+00 3.96831067e+00
+ 0.00000000e+00 0.00000000e+00 3.96831067e+00
+ 0.00000000e+00 0.00000000e+00 0.00000000e+00 3.96831067e+00
+ 0.00000000e+00 0.00000000e+00 0.00000000e+00 0.00000000e+00 3.96831067e+00
+ Go=
+ 0.00000000e+00
+ -0.00000000e+00 0.00000000e+00
+ -0.00000000e+00 -0.00000000e+00 0.00000000e+00
+ -0.00000000e+00 -0.00000000e+00 -0.00000000e+00 0.00000000e+00
+ -0.00000000e+00 -0.00000000e+00 -0.00000000e+00 -0.00000000e+00 0.00000000e+00
+ Rs=
+ 1.55902417e-03
+ -0.00000000e+00 1.55902417e-03
+ -0.00000000e+00 -0.00000000e+00 1.55902417e-03
+ -0.00000000e+00 -0.00000000e+00 -0.00000000e+00 1.55902417e-03
+ -0.00000000e+00 -0.00000000e+00 -0.00000000e+00 -0.00000000e+00 1.55902417e-03
+ Gd=
+ 2.03800971e-11
+ -2.46981913e-13 2.03598063e-11
+ -0.00000000e+00 -1.26004389e-13 2.03591965e-11
+ -0.00000000e+00 -0.00000000e+00 -2.54511439e-13 2.03573257e-11
+ -0.00000000e+00 -0.00000000e+00 -0.00000000e+00 -1.80676129e-13 2.03817957e-11

.Model Wmodel_Trace1695::MIPI_DSI1_DATA0_N W MODELTYPE=RLGC N=5
+ Lo=
+ 3.29324766e-07
+ 5.60790908e-08 3.28082347e-07
+ 1.39868411e-08 4.11703854e-08 3.27992431e-07
+ 6.53820056e-09 1.38886019e-08 5.57389557e-08 3.28076413e-07
+ 3.41105589e-09 5.74399707e-09 1.40577018e-08 4.16433246e-08 3.30620770e-07
+ Co=
+ 1.04292615e-10
+ -7.16823539e-12 1.04601781e-10
+ -5.76600469e-13 -4.39666804e-12 1.04606900e-10
+ -2.51748131e-13 -5.61804907e-13 -7.12829626e-12 1.04602012e-10
+ -1.44958855e-13 -2.41499169e-13 -5.86090314e-13 -4.45701542e-12 1.03816441e-10
+ Ro=
+ 3.96831067e+00
+ 0.00000000e+00 3.96831067e+00
+ 0.00000000e+00 0.00000000e+00 3.96831067e+00
+ 0.00000000e+00 0.00000000e+00 0.00000000e+00 3.96831067e+00
+ 0.00000000e+00 0.00000000e+00 0.00000000e+00 0.00000000e+00 3.96831067e+00
+ Go=
+ 0.00000000e+00
+ -0.00000000e+00 0.00000000e+00
+ -0.00000000e+00 -0.00000000e+00 0.00000000e+00
+ -0.00000000e+00 -0.00000000e+00 -0.00000000e+00 0.00000000e+00
+ -0.00000000e+00 -0.00000000e+00 -0.00000000e+00 -0.00000000e+00 0.00000000e+00
+ Rs=
+ 1.55902417e-03
+ -0.00000000e+00 1.55902417e-03
+ -0.00000000e+00 -0.00000000e+00 1.55902417e-03
+ -0.00000000e+00 -0.00000000e+00 -0.00000000e+00 1.55902417e-03
+ -0.00000000e+00 -0.00000000e+00 -0.00000000e+00 -0.00000000e+00 1.55902417e-03
+ Gd=
+ 2.03823244e-11
+ -4.85385610e-13 2.03601117e-11
+ -0.00000000e+00 -1.87398655e-13 2.03594907e-11
+ -0.00000000e+00 -0.00000000e+00 -4.89725950e-13 2.03600581e-11
+ -0.00000000e+00 -0.00000000e+00 -0.00000000e+00 -1.81941906e-13 2.03816859e-11

.Model Wmodel_Trace1695_Auto_701::MIPI_DSI1_DATA0_N W MODELTYPE=RLGC N=1
+ Lo=
+ 3.32029740e-07
+ Co=
+ 1.03489020e-10
+ Ro=
+ 3.96831067e+00
+ Go=
+ 0.00000000e+00
+ Rs=
+ 1.55902417e-03
+ Gd=
+ 2.04067990e-11

.Model Wmodel_Trace1697::MIPI_DSI1_DATA0_N W MODELTYPE=RLGC N=1
+ Lo=
+ 3.32029740e-07
+ Co=
+ 1.03489020e-10
+ Ro=
+ 3.96831067e+00
+ Go=
+ 0.00000000e+00
+ Rs=
+ 1.55902417e-03
+ Gd=
+ 2.04067990e-11

.Model Wmodel_Trace1699::MIPI_DSI1_DATA0_N W MODELTYPE=RLGC N=1
+ Lo=
+ 3.32029740e-07
+ Co=
+ 1.03489020e-10
+ Ro=
+ 3.96831067e+00
+ Go=
+ 0.00000000e+00
+ Rs=
+ 1.55902417e-03
+ Gd=
+ 2.04067990e-11

.Model Wmodel_Trace1701::MIPI_DSI1_DATA0_N W MODELTYPE=RLGC N=1
+ Lo=
+ 3.32029740e-07
+ Co=
+ 1.03489020e-10
+ Ro=
+ 3.96831067e+00
+ Go=
+ 0.00000000e+00
+ Rs=
+ 1.55902417e-03
+ Gd=
+ 2.04067990e-11

.Model Wmodel_Trace1701_Auto_326::MIPI_DSI1_DATA0_N W MODELTYPE=RLGC N=3
+ Lo=
+ 3.30678013e-07
+ 4.19117051e-08 3.29573316e-07
+ 1.17146736e-08 4.05620182e-08 3.30772389e-07
+ Co=
+ 1.03813365e-10
+ -4.48899799e-12 1.04092330e-10
+ -5.34297923e-13 -4.26282479e-12 1.03783203e-10
+ Ro=
+ 3.96831067e+00
+ 0.00000000e+00 3.96831067e+00
+ 0.00000000e+00 0.00000000e+00 3.96831067e+00
+ Go=
+ 0.00000000e+00
+ -0.00000000e+00 0.00000000e+00
+ -0.00000000e+00 -0.00000000e+00 0.00000000e+00
+ Rs=
+ 1.55902417e-03
+ -0.00000000e+00 1.55902417e-03
+ -0.00000000e+00 -0.00000000e+00 1.55902417e-03
+ Gd=
+ 2.03820241e-11
+ -1.79650524e-13 2.03605183e-11
+ -0.00000000e+00 -1.57580416e-13 2.03828756e-11

.Model Wmodel_Trace1702::MIPI_DSI1_DATA0_N W MODELTYPE=RLGC N=1
+ Lo=
+ 3.32029740e-07
+ Co=
+ 1.03489020e-10
+ Ro=
+ 3.96831067e+00
+ Go=
+ 0.00000000e+00
+ Rs=
+ 1.55902417e-03
+ Gd=
+ 2.04067990e-11

.Model Wmodel_Trace1710::MIPI_DSI1_DATA0_N W MODELTYPE=RLGC N=1
+ Lo=
+ 3.32029740e-07
+ Co=
+ 1.03489020e-10
+ Ro=
+ 3.96831067e+00
+ Go=
+ 0.00000000e+00
+ Rs=
+ 1.55902417e-03
+ Gd=
+ 2.04067990e-11

.Model Wmodel_Trace1710_Auto_321::MIPI_DSI1_DATA0_N W MODELTYPE=RLGC N=2
+ Lo=
+ 3.31090758e-07
+ 3.69663702e-08 3.31090758e-07
+ Co=
+ 1.03702334e-10
+ -3.67878977e-12 1.03702334e-10
+ Ro=
+ 3.96831067e+00
+ 0.00000000e+00 3.96831067e+00
+ Go=
+ 0.00000000e+00
+ -0.00000000e+00 0.00000000e+00
+ Rs=
+ 1.55902417e-03
+ -0.00000000e+00 1.55902417e-03
+ Gd=
+ 2.03864930e-11
+ -9.56893964e-14 2.03864930e-11

.Model Wmodel_Trace1710_Auto_322::MIPI_DSI1_DATA0_N W MODELTYPE=RLGC N=1
+ Lo=
+ 3.32029740e-07
+ Co=
+ 1.03489020e-10
+ Ro=
+ 3.96831067e+00
+ Go=
+ 0.00000000e+00
+ Rs=
+ 1.55902417e-03
+ Gd=
+ 2.04067990e-11

.Model Wmodel_Trace1714::MIPI_DSI1_DATA0_N W MODELTYPE=RLGC N=1
+ Lo=
+ 3.32029740e-07
+ Co=
+ 1.03489020e-10
+ Ro=
+ 3.96831067e+00
+ Go=
+ 0.00000000e+00
+ Rs=
+ 1.55902417e-03
+ Gd=
+ 2.04067990e-11

.Model Wmodel_Trace1718_Auto_317::MIPI_DSI1_DATA0_N W MODELTYPE=RLGC N=4
+ Lo=
+ 3.30666109e-07
+ 4.18833957e-08 3.29503290e-07
+ 1.16059104e-08 4.02731099e-08 3.29438407e-07
+ 5.19755260e-09 1.17593313e-08 4.28024227e-08 3.30596587e-07
+ Co=
+ 1.03814316e-10
+ -4.48683795e-12 1.04097255e-10
+ -5.18195170e-13 -4.22533300e-12 1.04118995e-10
+ -2.30131368e-13 -5.23456189e-13 -4.64401180e-12 1.03836453e-10
+ Ro=
+ 3.96831067e+00
+ 0.00000000e+00 3.96831067e+00
+ 0.00000000e+00 0.00000000e+00 3.96831067e+00
+ 0.00000000e+00 0.00000000e+00 0.00000000e+00 3.96831067e+00
+ Go=
+ 0.00000000e+00
+ -0.00000000e+00 0.00000000e+00
+ -0.00000000e+00 -0.00000000e+00 0.00000000e+00
+ -0.00000000e+00 -0.00000000e+00 -0.00000000e+00 0.00000000e+00
+ Rs=
+ 1.55902417e-03
+ -0.00000000e+00 1.55902417e-03
+ -0.00000000e+00 -0.00000000e+00 1.55902417e-03
+ -0.00000000e+00 -0.00000000e+00 -0.00000000e+00 1.55902417e-03
+ Gd=
+ 2.03818956e-11
+ -1.79934483e-13 2.03598884e-11
+ -0.00000000e+00 -1.61763358e-13 2.03594091e-11
+ -0.00000000e+00 -0.00000000e+00 -1.95918096e-13 2.03813611e-11

.Model Wmodel_Trace1719::MIPI_DSI1_DATA0_N W MODELTYPE=RLGC N=1
+ Lo=
+ 3.32029740e-07
+ Co=
+ 1.03489020e-10
+ Ro=
+ 3.96831067e+00
+ Go=
+ 0.00000000e+00
+ Rs=
+ 1.55902417e-03
+ Gd=
+ 2.04067990e-11

.Model Wmodel_Trace1724::MIPI_DSI1_DATA0_N W MODELTYPE=RLGC N=2
+ Lo=
+ 3.30798850e-07
+ 4.14572798e-08 3.30798850e-07
+ Co=
+ 1.03791658e-10
+ -4.40234673e-12 1.03791658e-10
+ Ro=
+ 3.96831067e+00
+ 0.00000000e+00 3.96831067e+00
+ Go=
+ 0.00000000e+00
+ -0.00000000e+00 0.00000000e+00
+ Rs=
+ 1.55902417e-03
+ -0.00000000e+00 1.55902417e-03
+ Gd=
+ 2.03831601e-11
+ -1.63329939e-13 2.03831601e-11

.Model Wmodel_Trace1725::MIPI_DSI1_DATA0_N W MODELTYPE=RLGC N=2
+ Lo=
+ 3.30798400e-07
+ 4.14636751e-08 3.30798400e-07
+ Co=
+ 1.03791802e-10
+ -4.40341733e-12 1.03791802e-10
+ Ro=
+ 3.96831067e+00
+ 0.00000000e+00 3.96831067e+00
+ Go=
+ 0.00000000e+00
+ -0.00000000e+00 0.00000000e+00
+ Rs=
+ 1.55902417e-03
+ -0.00000000e+00 1.55902417e-03
+ Gd=
+ 2.03831560e-11
+ -1.63435690e-13 2.03831560e-11

.Model Wmodel_Trace1726::MIPI_DSI1_DATA0_N W MODELTYPE=RLGC N=1
+ Lo=
+ 3.32029740e-07
+ Co=
+ 1.03489020e-10
+ Ro=
+ 3.96831067e+00
+ Go=
+ 0.00000000e+00
+ Rs=
+ 1.55902417e-03
+ Gd=
+ 2.04067990e-11

.Model Wmodel_Trace1727::MIPI_DSI1_DATA0_N W MODELTYPE=RLGC N=1
+ Lo=
+ 3.32029740e-07
+ Co=
+ 1.03489020e-10
+ Ro=
+ 3.96831067e+00
+ Go=
+ 0.00000000e+00
+ Rs=
+ 1.55902417e-03
+ Gd=
+ 2.04067990e-11

.Model Wmodel_Trace1731::MIPI_DSI1_DATA0_N W MODELTYPE=RLGC N=1
+ Lo=
+ 3.32029740e-07
+ Co=
+ 1.03489020e-10
+ Ro=
+ 3.96831067e+00
+ Go=
+ 0.00000000e+00
+ Rs=
+ 1.55902417e-03
+ Gd=
+ 2.04067990e-11

.Model Wmodel_Trace1733_Auto_373::MIPI_DSI1_DATA0_N W MODELTYPE=RLGC N=1
+ Lo=
+ 3.32029740e-07
+ Co=
+ 1.03489020e-10
+ Ro=
+ 3.96831067e+00
+ Go=
+ 0.00000000e+00
+ Rs=
+ 1.55902417e-03
+ Gd=
+ 2.04067990e-11

.Model Wmodel_Trace1735::MIPI_DSI1_DATA0_N W MODELTYPE=RLGC N=1
+ Lo=
+ 3.32029740e-07
+ Co=
+ 1.03489020e-10
+ Ro=
+ 3.96831067e+00
+ Go=
+ 0.00000000e+00
+ Rs=
+ 1.55902417e-03
+ Gd=
+ 2.04067990e-11

.Model Wmodel_Trace1742::MIPI_DSI1_DATA0_N W MODELTYPE=RLGC N=1
+ Lo=
+ 3.32029740e-07
+ Co=
+ 1.03489020e-10
+ Ro=
+ 3.96831067e+00
+ Go=
+ 0.00000000e+00
+ Rs=
+ 1.55902417e-03
+ Gd=
+ 2.04067990e-11

.Model Wmodel_Trace1743::MIPI_DSI1_DATA0_N W MODELTYPE=RLGC N=1
+ Lo=
+ 3.32029740e-07
+ Co=
+ 1.03489020e-10
+ Ro=
+ 3.96831067e+00
+ Go=
+ 0.00000000e+00
+ Rs=
+ 1.55902417e-03
+ Gd=
+ 2.04067990e-11

.Model Wmodel_Trace1743_Auto_1693::MIPI_DSI1_DATA0_N W MODELTYPE=RLGC N=1
+ Lo=
+ 3.32029740e-07
+ Co=
+ 1.03489020e-10
+ Ro=
+ 3.96831067e+00
+ Go=
+ 0.00000000e+00
+ Rs=
+ 1.55902417e-03
+ Gd=
+ 2.04067990e-11

.Model Wmodel_Trace1745::MIPI_DSI1_DATA0_N W MODELTYPE=RLGC N=1
+ Lo=
+ 3.32029740e-07
+ Co=
+ 1.03489020e-10
+ Ro=
+ 3.96831067e+00
+ Go=
+ 0.00000000e+00
+ Rs=
+ 1.55902417e-03
+ Gd=
+ 2.04067990e-11

.Model Wmodel_Trace1747::MIPI_DSI1_DATA0_N W MODELTYPE=RLGC N=1
+ Lo=
+ 3.32029740e-07
+ Co=
+ 1.03489020e-10
+ Ro=
+ 3.96831067e+00
+ Go=
+ 0.00000000e+00
+ Rs=
+ 1.55902417e-03
+ Gd=
+ 2.04067990e-11

.Model Wmodel_Trace1751::MIPI_DSI1_DATA0_N W MODELTYPE=RLGC N=1
+ Lo=
+ 3.32029740e-07
+ Co=
+ 1.03489020e-10
+ Ro=
+ 3.96831067e+00
+ Go=
+ 0.00000000e+00
+ Rs=
+ 1.55902417e-03
+ Gd=
+ 2.04067990e-11

.Model Wmodel_Trace1753::MIPI_DSI1_DATA0_N W MODELTYPE=RLGC N=1
+ Lo=
+ 3.32029740e-07
+ Co=
+ 1.03489020e-10
+ Ro=
+ 3.96831067e+00
+ Go=
+ 0.00000000e+00
+ Rs=
+ 1.55902417e-03
+ Gd=
+ 2.04067990e-11

.Model Wmodel_Trace1753_Auto_1725::MIPI_DSI1_DATA0_N W MODELTYPE=RLGC N=1
+ Lo=
+ 3.32029740e-07
+ Co=
+ 1.03489020e-10
+ Ro=
+ 3.96831067e+00
+ Go=
+ 0.00000000e+00
+ Rs=
+ 1.55902417e-03
+ Gd=
+ 2.04067990e-11

.Model Wmodel_Trace1755::MIPI_DSI1_DATA0_N W MODELTYPE=RLGC N=1
+ Lo=
+ 3.32029740e-07
+ Co=
+ 1.03489020e-10
+ Ro=
+ 3.96831067e+00
+ Go=
+ 0.00000000e+00
+ Rs=
+ 1.55902417e-03
+ Gd=
+ 2.04067990e-11

.Model Wmodel_Trace1756::MIPI_DSI1_DATA0_N W MODELTYPE=RLGC N=1
+ Lo=
+ 8.24350330e-07
+ Co=
+ 3.67394016e-11
+ Ro=
+ 3.96831067e+00
+ Go=
+ 0.00000000e+00
+ Rs=
+ 1.02517469e-03
+ Gd=
+ 6.50321060e-12

.Model Wmodel_Trace1761::MIPI_DSI1_DATA0_N W MODELTYPE=RLGC N=1
+ Lo=
+ 3.32029740e-07
+ Co=
+ 1.03489020e-10
+ Ro=
+ 3.96831067e+00
+ Go=
+ 0.00000000e+00
+ Rs=
+ 1.55902417e-03
+ Gd=
+ 2.04067990e-11

.Model Wmodel_Trace1762#BP0::MIPI_DSI1_DATA0_N W MODELTYPE=RLGC N=1
+ Lo=
+ 3.32029740e-07
+ Co=
+ 1.03489020e-10
+ Ro=
+ 3.96831067e+00
+ Go=
+ 0.00000000e+00
+ Rs=
+ 1.55902417e-03
+ Gd=
+ 2.04067990e-11

.Model Wmodel_Trace1762::MIPI_DSI1_DATA0_N W MODELTYPE=RLGC N=1
+ Lo=
+ 8.24350330e-07
+ Co=
+ 3.67394016e-11
+ Ro=
+ 3.96831067e+00
+ Go=
+ 0.00000000e+00
+ Rs=
+ 1.02517469e-03
+ Gd=
+ 6.50321060e-12

.Model Wmodel_Trace1764::MIPI_DSI1_DATA0_N W MODELTYPE=RLGC N=1
+ Lo=
+ 3.32029740e-07
+ Co=
+ 1.03489020e-10
+ Ro=
+ 3.96831067e+00
+ Go=
+ 0.00000000e+00
+ Rs=
+ 1.55902417e-03
+ Gd=
+ 2.04067990e-11

.Model Wmodel_Trace1764_Auto_1722::MIPI_DSI1_DATA0_N W MODELTYPE=RLGC N=4
+ Lo=
+ 3.30627493e-07
+ 4.22908879e-08 3.29307047e-07
+ 1.20651161e-08 4.25176377e-08 3.29306647e-07
+ 5.30745314e-09 1.20661150e-08 4.22965830e-08 3.30627061e-07
+ Co=
+ 1.03825008e-10
+ -4.55749349e-12 1.04159465e-10
+ -5.32788704e-13 -4.60629983e-12 1.04159599e-10
+ -2.34583083e-13 -5.32822589e-13 -4.55846746e-12 1.03825145e-10
+ Ro=
+ 3.96831067e+00
+ 0.00000000e+00 3.96831067e+00
+ 0.00000000e+00 0.00000000e+00 3.96831067e+00
+ 0.00000000e+00 0.00000000e+00 0.00000000e+00 3.96831067e+00
+ Go=
+ 0.00000000e+00
+ -0.00000000e+00 0.00000000e+00
+ -0.00000000e+00 -0.00000000e+00 0.00000000e+00
+ -0.00000000e+00 -0.00000000e+00 -0.00000000e+00 0.00000000e+00
+ Rs=
+ 1.55902417e-03
+ -0.00000000e+00 1.55902417e-03
+ -0.00000000e+00 -0.00000000e+00 1.55902417e-03
+ -0.00000000e+00 -0.00000000e+00 -0.00000000e+00 1.55902417e-03
+ Gd=
+ 2.03816056e-11
+ -1.87776818e-13 2.03583440e-11
+ -0.00000000e+00 -2.00127630e-13 2.03583410e-11
+ -0.00000000e+00 -0.00000000e+00 -1.87875863e-13 2.03816023e-11

.Model Wmodel_Trace1764_Auto_1723::MIPI_DSI1_DATA0_N W MODELTYPE=RLGC N=1
+ Lo=
+ 3.32029740e-07
+ Co=
+ 1.03489020e-10
+ Ro=
+ 3.96831067e+00
+ Go=
+ 0.00000000e+00
+ Rs=
+ 1.55902417e-03
+ Gd=
+ 2.04067990e-11

.Model Wmodel_Trace1773::MIPI_DSI1_DATA0_N W MODELTYPE=RLGC N=1
+ Lo=
+ 3.32029740e-07
+ Co=
+ 1.03489020e-10
+ Ro=
+ 3.96831067e+00
+ Go=
+ 0.00000000e+00
+ Rs=
+ 1.55902417e-03
+ Gd=
+ 2.04067990e-11

.Model Wmodel_Trace1775::MIPI_DSI1_DATA0_N W MODELTYPE=RLGC N=1
+ Lo=
+ 3.32029740e-07
+ Co=
+ 1.03489020e-10
+ Ro=
+ 3.96831067e+00
+ Go=
+ 0.00000000e+00
+ Rs=
+ 1.55902417e-03
+ Gd=
+ 2.04067990e-11

.Model Wmodel_Trace1775_Auto_1704::MIPI_DSI1_DATA0_N W MODELTYPE=RLGC N=1
+ Lo=
+ 3.32029740e-07
+ Co=
+ 1.03489020e-10
+ Ro=
+ 3.96831067e+00
+ Go=
+ 0.00000000e+00
+ Rs=
+ 1.55902417e-03
+ Gd=
+ 2.04067990e-11

.Model Wmodel_Trace1777::MIPI_DSI1_DATA0_N W MODELTYPE=RLGC N=1
+ Lo=
+ 3.32029740e-07
+ Co=
+ 1.03489020e-10
+ Ro=
+ 3.96831067e+00
+ Go=
+ 0.00000000e+00
+ Rs=
+ 1.55902417e-03
+ Gd=
+ 2.04067990e-11

.Model Wmodel_Trace1786::MIPI_DSI1_DATA0_N W MODELTYPE=RLGC N=1
+ Lo=
+ 3.32029740e-07
+ Co=
+ 1.03489020e-10
+ Ro=
+ 3.96831067e+00
+ Go=
+ 0.00000000e+00
+ Rs=
+ 1.55902417e-03
+ Gd=
+ 2.04067990e-11

.Model Wmodel_Trace1786_Auto_1702::MIPI_DSI1_DATA0_N W MODELTYPE=RLGC N=1
+ Lo=
+ 3.32029740e-07
+ Co=
+ 1.03489020e-10
+ Ro=
+ 3.96831067e+00
+ Go=
+ 0.00000000e+00
+ Rs=
+ 1.55902417e-03
+ Gd=
+ 2.04067990e-11

.Model Wmodel_Trace1786_Auto_1715::MIPI_DSI1_DATA0_N W MODELTYPE=RLGC N=8
+ Lo=
+ 3.30621759e-07
+ 4.23011126e-08 3.29295353e-07
+ 1.20512568e-08 4.24768056e-08 3.29260823e-07
+ 5.27135098e-09 1.20003065e-08 4.21611339e-08 3.30197819e-07
+ 2.46078739e-09 4.17149901e-09 8.59825414e-09 2.49124967e-08 3.30235357e-07
+ 1.60706487e-09 2.42824323e-09 4.14045882e-09 8.55190160e-09 4.17133122e-08 3.29388898e-07
+ 1.13211875e-09 1.58527377e-09 2.40852652e-09 4.11192941e-09 1.17127937e-08 4.12480472e-08 3.29424159e-07
+ 8.50530526e-10 1.12964493e-09 1.59250023e-09 2.42676214e-09 5.16440534e-09 1.17611697e-08 4.18415069e-08 3.30661150e-07
+ Co=
+ 1.03825843e-10
+ -4.55981907e-12 1.04160444e-10
+ -5.31542617e-13 -4.60130286e-12 1.04163043e-10
+ -2.29843641e-13 -5.25119365e-13 -4.54272178e-12 1.03897826e-10
+ -1.12156206e-13 -1.84836504e-13 -3.96894446e-13 -2.02301441e-12 1.03886676e-10
+ -7.05783115e-14 -1.02468049e-13 -1.75243623e-13 -3.95719891e-13 -4.46559143e-12 1.04122587e-10
+ -5.00180792e-14 -6.71001767e-14 -1.01793225e-13 -1.83009304e-13 -5.16454579e-13 -4.39056283e-12 1.04119709e-10
+ -3.92573848e-14 -4.97799958e-14 -6.98438682e-14 -1.10751933e-13 -2.26214000e-13 -5.22769842e-13 -4.48072147e-12 1.03814313e-10
+ Ro=
+ 3.96831067e+00
+ 0.00000000e+00 3.96831067e+00
+ 0.00000000e+00 0.00000000e+00 3.96831067e+00
+ 0.00000000e+00 0.00000000e+00 0.00000000e+00 3.96831067e+00
+ 0.00000000e+00 0.00000000e+00 0.00000000e+00 0.00000000e+00 3.96831067e+00
+ 0.00000000e+00 0.00000000e+00 0.00000000e+00 0.00000000e+00 0.00000000e+00 3.96831067e+00
+ 0.00000000e+00 0.00000000e+00 0.00000000e+00 0.00000000e+00 0.00000000e+00 0.00000000e+00 3.96831067e+00
+ 0.00000000e+00 0.00000000e+00 0.00000000e+00 0.00000000e+00 0.00000000e+00 0.00000000e+00 0.00000000e+00 3.96831067e+00
+ Go=
+ 0.00000000e+00
+ -0.00000000e+00 0.00000000e+00
+ -0.00000000e+00 -0.00000000e+00 0.00000000e+00
+ -0.00000000e+00 -0.00000000e+00 -0.00000000e+00 0.00000000e+00
+ -0.00000000e+00 -0.00000000e+00 -0.00000000e+00 -0.00000000e+00 0.00000000e+00
+ -0.00000000e+00 -0.00000000e+00 -0.00000000e+00 -0.00000000e+00 -0.00000000e+00 0.00000000e+00
+ -0.00000000e+00 -0.00000000e+00 -0.00000000e+00 -0.00000000e+00 -0.00000000e+00 -0.00000000e+00 0.00000000e+00
+ -0.00000000e+00 -0.00000000e+00 -0.00000000e+00 -0.00000000e+00 -0.00000000e+00 -0.00000000e+00 -0.00000000e+00 0.00000000e+00
+ Rs=
+ 1.55902417e-03
+ -0.00000000e+00 1.55902417e-03
+ -0.00000000e+00 -0.00000000e+00 1.55902417e-03
+ -0.00000000e+00 -0.00000000e+00 -0.00000000e+00 1.55902417e-03
+ -0.00000000e+00 -0.00000000e+00 -0.00000000e+00 -0.00000000e+00 1.55902417e-03
+ -0.00000000e+00 -0.00000000e+00 -0.00000000e+00 -0.00000000e+00 -0.00000000e+00 1.55902417e-03
+ -0.00000000e+00 -0.00000000e+00 -0.00000000e+00 -0.00000000e+00 -0.00000000e+00 -0.00000000e+00 1.55902417e-03
+ -0.00000000e+00 -0.00000000e+00 -0.00000000e+00 -0.00000000e+00 -0.00000000e+00 -0.00000000e+00 -0.00000000e+00 1.55902417e-03
+ Gd=
+ 2.03815344e-11
+ -1.88165106e-13 2.03582072e-11
+ -0.00000000e+00 -2.00086734e-13 2.03578129e-11
+ -0.00000000e+00 -0.00000000e+00 -1.90114533e-13 2.03715095e-11
+ -0.00000000e+00 -0.00000000e+00 -0.00000000e+00 -0.00000000e+00 2.03717900e-11
+ -0.00000000e+00 -0.00000000e+00 -0.00000000e+00 -0.00000000e+00 -1.81919712e-13 2.03587594e-11
+ -0.00000000e+00 -0.00000000e+00 -0.00000000e+00 -0.00000000e+00 -0.00000000e+00 -1.78366028e-13 2.03591613e-11
+ -0.00000000e+00 -0.00000000e+00 -0.00000000e+00 -0.00000000e+00 -0.00000000e+00 -0.00000000e+00 -1.79767612e-13 2.03818372e-11

.Model Wmodel_Trace1792::MIPI_DSI1_DATA0_N W MODELTYPE=RLGC N=1
+ Lo=
+ 3.32029740e-07
+ Co=
+ 1.03489020e-10
+ Ro=
+ 3.96831067e+00
+ Go=
+ 0.00000000e+00
+ Rs=
+ 1.55902417e-03
+ Gd=
+ 2.04067990e-11

.Model Wmodel_Trace1793::MIPI_DSI1_DATA0_N W MODELTYPE=RLGC N=1
+ Lo=
+ 3.32029740e-07
+ Co=
+ 1.03489020e-10
+ Ro=
+ 3.96831067e+00
+ Go=
+ 0.00000000e+00
+ Rs=
+ 1.55902417e-03
+ Gd=
+ 2.04067990e-11

.Model Wmodel_Trace1793_Auto_1916::MIPI_DSI1_DATA0_N W MODELTYPE=RLGC N=1
+ Lo=
+ 3.32029740e-07
+ Co=
+ 1.03489020e-10
+ Ro=
+ 3.96831067e+00
+ Go=
+ 0.00000000e+00
+ Rs=
+ 1.55902417e-03
+ Gd=
+ 2.04067990e-11

.Model Wmodel_Trace1795::MIPI_DSI1_DATA0_N W MODELTYPE=RLGC N=1
+ Lo=
+ 3.32029740e-07
+ Co=
+ 1.03489020e-10
+ Ro=
+ 3.96831067e+00
+ Go=
+ 0.00000000e+00
+ Rs=
+ 1.55902417e-03
+ Gd=
+ 2.04067990e-11

.Model Wmodel_Trace1798::MIPI_DSI1_DATA0_N W MODELTYPE=RLGC N=1
+ Lo=
+ 3.32029740e-07
+ Co=
+ 1.03489020e-10
+ Ro=
+ 3.96831067e+00
+ Go=
+ 0.00000000e+00
+ Rs=
+ 1.55902417e-03
+ Gd=
+ 2.04067990e-11

.Model Wmodel_Trace1801::MIPI_DSI1_DATA0_N W MODELTYPE=RLGC N=1
+ Lo=
+ 3.32029740e-07
+ Co=
+ 1.03489020e-10
+ Ro=
+ 3.96831067e+00
+ Go=
+ 0.00000000e+00
+ Rs=
+ 1.55902417e-03
+ Gd=
+ 2.04067990e-11

.Model Wmodel_Trace1806::MIPI_DSI1_DATA0_N W MODELTYPE=RLGC N=1
+ Lo=
+ 3.32029740e-07
+ Co=
+ 1.03489020e-10
+ Ro=
+ 3.96831067e+00
+ Go=
+ 0.00000000e+00
+ Rs=
+ 1.55902417e-03
+ Gd=
+ 2.04067990e-11

.Model Wmodel_Trace1806_Auto_1926::MIPI_DSI1_DATA0_N W MODELTYPE=RLGC N=2
+ Lo=
+ 3.30748548e-07
+ 4.21643405e-08 3.30748548e-07
+ Co=
+ 1.03807831e-10
+ -4.52139143e-12 1.03807831e-10
+ Ro=
+ 3.96831067e+00
+ 0.00000000e+00 3.96831067e+00
+ Go=
+ 0.00000000e+00
+ -0.00000000e+00 0.00000000e+00
+ Rs=
+ 1.55902417e-03
+ -0.00000000e+00 1.55902417e-03
+ Gd=
+ 2.03827231e-11
+ -1.75180973e-13 2.03827231e-11

.Model Wmodel_Trace1808::MIPI_DSI1_DATA0_N W MODELTYPE=RLGC N=1
+ Lo=
+ 3.32029740e-07
+ Co=
+ 1.03489020e-10
+ Ro=
+ 3.96831067e+00
+ Go=
+ 0.00000000e+00
+ Rs=
+ 1.55902417e-03
+ Gd=
+ 2.04067990e-11

.Model Wmodel_Trace1812::MIPI_DSI1_DATA0_N W MODELTYPE=RLGC N=1
+ Lo=
+ 3.32029740e-07
+ Co=
+ 1.03489020e-10
+ Ro=
+ 3.96831067e+00
+ Go=
+ 0.00000000e+00
+ Rs=
+ 1.55902417e-03
+ Gd=
+ 2.04067990e-11

.Model Wmodel_Trace1813::MIPI_DSI1_DATA0_N W MODELTYPE=RLGC N=1
+ Lo=
+ 3.32029740e-07
+ Co=
+ 1.03489020e-10
+ Ro=
+ 3.96831067e+00
+ Go=
+ 0.00000000e+00
+ Rs=
+ 1.55902417e-03
+ Gd=
+ 2.04067990e-11

.Model Wmodel_Trace1814_Auto_2045::MIPI_DSI1_DATA0_N W MODELTYPE=RLGC N=1
+ Lo=
+ 3.32029740e-07
+ Co=
+ 1.03489020e-10
+ Ro=
+ 3.96831067e+00
+ Go=
+ 0.00000000e+00
+ Rs=
+ 1.55902417e-03
+ Gd=
+ 2.04067990e-11

.Model Wmodel_Trace1814_Auto_2048::MIPI_DSI1_DATA0_N W MODELTYPE=RLGC N=1
+ Lo=
+ 3.32029740e-07
+ Co=
+ 1.03489020e-10
+ Ro=
+ 3.96831067e+00
+ Go=
+ 0.00000000e+00
+ Rs=
+ 1.55902417e-03
+ Gd=
+ 2.04067990e-11

.Model Wmodel_Trace1815::MIPI_DSI1_DATA0_N W MODELTYPE=RLGC N=1
+ Lo=
+ 3.32029740e-07
+ Co=
+ 1.03489020e-10
+ Ro=
+ 3.96831067e+00
+ Go=
+ 0.00000000e+00
+ Rs=
+ 1.55902417e-03
+ Gd=
+ 2.04067990e-11

.Model Wmodel_Trace1815_Auto_1946::MIPI_DSI1_DATA0_N W MODELTYPE=RLGC N=6
+ Lo=
+ 3.31446168e-07
+ 2.91853593e-08 3.30890499e-07
+ 7.77232442e-09 2.89857796e-08 3.30147710e-07
+ 3.90199589e-09 9.48438750e-09 4.19034097e-08 3.30416093e-07
+ 1.91403408e-09 3.40648438e-09 7.77886878e-09 2.12115043e-08 3.31183258e-07
+ 1.22866854e-09 1.91293624e-09 3.42996669e-09 6.50838262e-09 2.92525577e-08 3.31456222e-07
+ Co=
+ 1.03599988e-10
+ -2.56467799e-12 1.03706853e-10
+ -3.79948892e-13 -2.53574651e-12 1.03918146e-10
+ -1.81302002e-13 -4.44931989e-13 -4.48909439e-12 1.03857415e-10
+ -9.35536163e-14 -1.64388049e-13 -3.72783302e-13 -1.60695470e-12 1.03644098e-10
+ -6.04100603e-14 -9.19083007e-14 -1.59330205e-13 -3.25549241e-13 -2.57395970e-12 1.03599265e-10
+ Ro=
+ 3.96831067e+00
+ 0.00000000e+00 3.96831067e+00
+ 0.00000000e+00 0.00000000e+00 3.96831067e+00
+ 0.00000000e+00 0.00000000e+00 0.00000000e+00 3.96831067e+00
+ 0.00000000e+00 0.00000000e+00 0.00000000e+00 0.00000000e+00 3.96831067e+00
+ 0.00000000e+00 0.00000000e+00 0.00000000e+00 0.00000000e+00 0.00000000e+00 3.96831067e+00
+ Go=
+ 0.00000000e+00
+ -0.00000000e+00 0.00000000e+00
+ -0.00000000e+00 -0.00000000e+00 0.00000000e+00
+ -0.00000000e+00 -0.00000000e+00 -0.00000000e+00 0.00000000e+00
+ -0.00000000e+00 -0.00000000e+00 -0.00000000e+00 -0.00000000e+00 0.00000000e+00
+ -0.00000000e+00 -0.00000000e+00 -0.00000000e+00 -0.00000000e+00 -0.00000000e+00 0.00000000e+00
+ Rs=
+ 1.55902417e-03
+ -0.00000000e+00 1.55902417e-03
+ -0.00000000e+00 -0.00000000e+00 1.55902417e-03
+ -0.00000000e+00 -0.00000000e+00 -0.00000000e+00 1.55902417e-03
+ -0.00000000e+00 -0.00000000e+00 -0.00000000e+00 -0.00000000e+00 1.55902417e-03
+ -0.00000000e+00 -0.00000000e+00 -0.00000000e+00 -0.00000000e+00 -0.00000000e+00 1.55902417e-03
+ Gd=
+ 2.03927275e-11
+ -1.46438073e-14 2.03794702e-11
+ -0.00000000e+00 -1.83717543e-14 2.03689839e-11
+ -0.00000000e+00 -0.00000000e+00 -1.79614207e-13 2.03751323e-11
+ -0.00000000e+00 -0.00000000e+00 -0.00000000e+00 -0.00000000e+00 2.03859132e-11
+ -0.00000000e+00 -0.00000000e+00 -0.00000000e+00 -0.00000000e+00 -1.38321874e-14 2.03928312e-11

.Model Wmodel_Trace1815_Auto_1947::MIPI_DSI1_DATA0_N W MODELTYPE=RLGC N=1
+ Lo=
+ 3.32029740e-07
+ Co=
+ 1.03489020e-10
+ Ro=
+ 3.96831067e+00
+ Go=
+ 0.00000000e+00
+ Rs=
+ 1.55902417e-03
+ Gd=
+ 2.04067990e-11

.Model Wmodel_Trace1816::MIPI_DSI1_DATA0_P W MODELTYPE=RLGC N=1
+ Lo=
+ 3.32029740e-07
+ Co=
+ 1.03489020e-10
+ Ro=
+ 3.96831067e+00
+ Go=
+ 0.00000000e+00
+ Rs=
+ 1.55902417e-03
+ Gd=
+ 2.04067990e-11

.Model Wmodel_Trace1817::MIPI_DSI1_DATA0_P W MODELTYPE=RLGC N=1
+ Lo=
+ 3.32029740e-07
+ Co=
+ 1.03489020e-10
+ Ro=
+ 3.96831067e+00
+ Go=
+ 0.00000000e+00
+ Rs=
+ 1.55902417e-03
+ Gd=
+ 2.04067990e-11

.Model Wmodel_Trace1818::MIPI_DSI1_DATA0_P W MODELTYPE=RLGC N=1
+ Lo=
+ 3.32029740e-07
+ Co=
+ 1.03489020e-10
+ Ro=
+ 3.96831067e+00
+ Go=
+ 0.00000000e+00
+ Rs=
+ 1.55902417e-03
+ Gd=
+ 2.04067990e-11

.Model Wmodel_Trace1818_Auto_1692::MIPI_DSI1_DATA0_P W MODELTYPE=RLGC N=2
+ Lo=
+ 3.30714784e-07
+ 4.26296736e-08 3.30714784e-07
+ Co=
+ 1.03818806e-10
+ -4.60048301e-12 1.03818806e-10
+ Ro=
+ 3.96831067e+00
+ 0.00000000e+00 3.96831067e+00
+ Go=
+ 0.00000000e+00
+ -0.00000000e+00 0.00000000e+00
+ Rs=
+ 1.55902417e-03
+ -0.00000000e+00 1.55902417e-03
+ Gd=
+ 2.03824516e-11
+ -1.83155133e-13 2.03824516e-11

.Model Wmodel_Trace1820::MIPI_DSI1_DATA0_P W MODELTYPE=RLGC N=1
+ Lo=
+ 3.32029740e-07
+ Co=
+ 1.03489020e-10
+ Ro=
+ 3.96831067e+00
+ Go=
+ 0.00000000e+00
+ Rs=
+ 1.55902417e-03
+ Gd=
+ 2.04067990e-11

.Model Wmodel_Trace1822::MIPI_DSI1_DATA0_P W MODELTYPE=RLGC N=1
+ Lo=
+ 3.32029740e-07
+ Co=
+ 1.03489020e-10
+ Ro=
+ 3.96831067e+00
+ Go=
+ 0.00000000e+00
+ Rs=
+ 1.55902417e-03
+ Gd=
+ 2.04067990e-11

.Model Wmodel_Trace1822_Auto_1695::MIPI_DSI1_DATA0_P W MODELTYPE=RLGC N=2
+ Lo=
+ 3.30706195e-07
+ 4.27469084e-08 3.30706195e-07
+ Co=
+ 1.03821613e-10
+ -4.62050205e-12 1.03821613e-10
+ Ro=
+ 3.96831067e+00
+ 0.00000000e+00 3.96831067e+00
+ Go=
+ 0.00000000e+00
+ -0.00000000e+00 0.00000000e+00
+ Rs=
+ 1.55902417e-03
+ -0.00000000e+00 1.55902417e-03
+ Gd=
+ 2.03823853e-11
+ -1.85185887e-13 2.03823853e-11

.Model Wmodel_Trace1822_Auto_1696::MIPI_DSI1_DATA0_P W MODELTYPE=RLGC N=1
+ Lo=
+ 3.32029740e-07
+ Co=
+ 1.03489020e-10
+ Ro=
+ 3.96831067e+00
+ Go=
+ 0.00000000e+00
+ Rs=
+ 1.55902417e-03
+ Gd=
+ 2.04067990e-11

.Model Wmodel_Trace1824::MIPI_DSI1_DATA0_P W MODELTYPE=RLGC N=1
+ Lo=
+ 3.32029740e-07
+ Co=
+ 1.03489020e-10
+ Ro=
+ 3.96831067e+00
+ Go=
+ 0.00000000e+00
+ Rs=
+ 1.55902417e-03
+ Gd=
+ 2.04067990e-11

.Model Wmodel_Trace1828::MIPI_DSI1_DATA0_P W MODELTYPE=RLGC N=1
+ Lo=
+ 3.32029740e-07
+ Co=
+ 1.03489020e-10
+ Ro=
+ 3.96831067e+00
+ Go=
+ 0.00000000e+00
+ Rs=
+ 1.55902417e-03
+ Gd=
+ 2.04067990e-11

.Model Wmodel_Trace1837::MIPI_DSI1_DATA0_P W MODELTYPE=RLGC N=1
+ Lo=
+ 3.32029740e-07
+ Co=
+ 1.03489020e-10
+ Ro=
+ 3.96831067e+00
+ Go=
+ 0.00000000e+00
+ Rs=
+ 1.55902417e-03
+ Gd=
+ 2.04067990e-11

.Model Wmodel_Trace1839_Auto_1706::MIPI_DSI1_DATA0_P W MODELTYPE=RLGC N=1
+ Lo=
+ 3.32029740e-07
+ Co=
+ 1.03489020e-10
+ Ro=
+ 3.96831067e+00
+ Go=
+ 0.00000000e+00
+ Rs=
+ 1.55902417e-03
+ Gd=
+ 2.04067990e-11

.Model Wmodel_Trace1841::MIPI_DSI1_DATA0_P W MODELTYPE=RLGC N=1
+ Lo=
+ 3.32029740e-07
+ Co=
+ 1.03489020e-10
+ Ro=
+ 3.96831067e+00
+ Go=
+ 0.00000000e+00
+ Rs=
+ 1.55902417e-03
+ Gd=
+ 2.04067990e-11

.Model Wmodel_Trace1850_Auto_1703::MIPI_DSI1_DATA0_P W MODELTYPE=RLGC N=1
+ Lo=
+ 3.32029740e-07
+ Co=
+ 1.03489020e-10
+ Ro=
+ 3.96831067e+00
+ Go=
+ 0.00000000e+00
+ Rs=
+ 1.55902417e-03
+ Gd=
+ 2.04067990e-11

.Model Wmodel_Trace1859::MIPI_DSI1_DATA0_P W MODELTYPE=RLGC N=1
+ Lo=
+ 3.32029740e-07
+ Co=
+ 1.03489020e-10
+ Ro=
+ 3.96831067e+00
+ Go=
+ 0.00000000e+00
+ Rs=
+ 1.55902417e-03
+ Gd=
+ 2.04067990e-11

.Model Wmodel_Trace1861_Auto_1701::MIPI_DSI1_DATA0_P W MODELTYPE=RLGC N=1
+ Lo=
+ 3.32029740e-07
+ Co=
+ 1.03489020e-10
+ Ro=
+ 3.96831067e+00
+ Go=
+ 0.00000000e+00
+ Rs=
+ 1.55902417e-03
+ Gd=
+ 2.04067990e-11

.Model Wmodel_Trace1861_Auto_1719::MIPI_DSI1_DATA0_P W MODELTYPE=RLGC N=2
+ Lo=
+ 3.31116770e-07
+ 3.65277767e-08 3.31116770e-07
+ Co=
+ 1.03694778e-10
+ -3.61120304e-12 1.03694778e-10
+ Ro=
+ 3.96831067e+00
+ 0.00000000e+00 3.96831067e+00
+ Go=
+ 0.00000000e+00
+ -0.00000000e+00 0.00000000e+00
+ Rs=
+ 1.55902417e-03
+ -0.00000000e+00 1.55902417e-03
+ Gd=
+ 2.03868582e-11
+ -8.98036913e-14 2.03868582e-11

.Model Wmodel_Trace1866::MIPI_DSI1_DATA0_P W MODELTYPE=RLGC N=1
+ Lo=
+ 3.32029740e-07
+ Co=
+ 1.03489020e-10
+ Ro=
+ 3.96831067e+00
+ Go=
+ 0.00000000e+00
+ Rs=
+ 1.55902417e-03
+ Gd=
+ 2.04067990e-11

.Model Wmodel_Trace1868::MIPI_DSI1_DATA0_P W MODELTYPE=RLGC N=2
+ Lo=
+ 3.30715033e-07
+ 4.26262708e-08 3.30715033e-07
+ Co=
+ 1.03818725e-10
+ -4.59990250e-12 1.03818725e-10
+ Ro=
+ 3.96831067e+00
+ 0.00000000e+00 3.96831067e+00
+ Go=
+ 0.00000000e+00
+ -0.00000000e+00 0.00000000e+00
+ Rs=
+ 1.55902417e-03
+ -0.00000000e+00 1.55902417e-03
+ Gd=
+ 2.03824535e-11
+ -1.83096319e-13 2.03824535e-11

.Model Wmodel_Trace1872::MIPI_DSI1_DATA0_P W MODELTYPE=RLGC N=1
+ Lo=
+ 3.32029740e-07
+ Co=
+ 1.03489020e-10
+ Ro=
+ 3.96831067e+00
+ Go=
+ 0.00000000e+00
+ Rs=
+ 1.55902417e-03
+ Gd=
+ 2.04067990e-11

.Model Wmodel_Trace1875::MIPI_DSI1_DATA0_P W MODELTYPE=RLGC N=4
+ Lo=
+ 3.30596478e-07
+ 4.27965572e-08 3.29427604e-07
+ 1.17862324e-08 4.04295368e-08 3.29493428e-07
+ 5.20441597e-09 1.16299214e-08 4.18636161e-08 3.30667043e-07
+ Co=
+ 1.03836379e-10
+ -4.64308880e-12 1.04122319e-10
+ -5.24319694e-13 -4.25141743e-12 1.04100264e-10
+ -2.30422896e-13 -5.18962868e-13 -4.48355986e-12 1.03813918e-10
+ Ro=
+ 3.96831067e+00
+ 0.00000000e+00 3.96831067e+00
+ 0.00000000e+00 0.00000000e+00 3.96831067e+00
+ 0.00000000e+00 0.00000000e+00 0.00000000e+00 3.96831067e+00
+ Go=
+ 0.00000000e+00
+ -0.00000000e+00 0.00000000e+00
+ -0.00000000e+00 -0.00000000e+00 0.00000000e+00
+ -0.00000000e+00 -0.00000000e+00 -0.00000000e+00 0.00000000e+00
+ Rs=
+ 1.55902417e-03
+ -0.00000000e+00 1.55902417e-03
+ -0.00000000e+00 -0.00000000e+00 1.55902417e-03
+ -0.00000000e+00 -0.00000000e+00 -0.00000000e+00 1.55902417e-03
+ Gd=
+ 2.03813611e-11
+ -1.95871759e-13 2.03593107e-11
+ -0.00000000e+00 -1.64324597e-13 2.03597976e-11
+ -0.00000000e+00 -0.00000000e+00 -1.79651864e-13 2.03819044e-11

.Model Wmodel_Trace1875_Auto_1922::MIPI_DSI1_DATA0_P W MODELTYPE=RLGC N=1
+ Lo=
+ 3.32029740e-07
+ Co=
+ 1.03489020e-10
+ Ro=
+ 3.96831067e+00
+ Go=
+ 0.00000000e+00
+ Rs=
+ 1.55902417e-03
+ Gd=
+ 2.04067990e-11

.Model Wmodel_Trace1876::MIPI_DSI1_DATA0_P W MODELTYPE=RLGC N=1
+ Lo=
+ 3.32029740e-07
+ Co=
+ 1.03489020e-10
+ Ro=
+ 3.96831067e+00
+ Go=
+ 0.00000000e+00
+ Rs=
+ 1.55902417e-03
+ Gd=
+ 2.04067990e-11

.Model Wmodel_Trace1878::MIPI_DSI1_DATA0_P W MODELTYPE=RLGC N=1
+ Lo=
+ 3.32029740e-07
+ Co=
+ 1.03489020e-10
+ Ro=
+ 3.96831067e+00
+ Go=
+ 0.00000000e+00
+ Rs=
+ 1.55902417e-03
+ Gd=
+ 2.04067990e-11

.Model Wmodel_Trace1878_Auto_1919::MIPI_DSI1_DATA0_P W MODELTYPE=RLGC N=2
+ Lo=
+ 3.30748904e-07
+ 4.21593990e-08 3.30748904e-07
+ Co=
+ 1.03807716e-10
+ -4.52055469e-12 1.03807716e-10
+ Ro=
+ 3.96831067e+00
+ 0.00000000e+00 3.96831067e+00
+ Go=
+ 0.00000000e+00
+ -0.00000000e+00 0.00000000e+00
+ Rs=
+ 1.55902417e-03
+ -0.00000000e+00 1.55902417e-03
+ Gd=
+ 2.03827260e-11
+ -1.75097034e-13 2.03827260e-11

.Model Wmodel_Trace1878_Auto_1920::MIPI_DSI1_DATA0_P W MODELTYPE=RLGC N=1
+ Lo=
+ 3.32029740e-07
+ Co=
+ 1.03489020e-10
+ Ro=
+ 3.96831067e+00
+ Go=
+ 0.00000000e+00
+ Rs=
+ 1.55902417e-03
+ Gd=
+ 2.04067990e-11

.Model Wmodel_Trace1879::MIPI_DSI1_DATA0_P W MODELTYPE=RLGC N=1
+ Lo=
+ 3.32029740e-07
+ Co=
+ 1.03489020e-10
+ Ro=
+ 3.96831067e+00
+ Go=
+ 0.00000000e+00
+ Rs=
+ 1.55902417e-03
+ Gd=
+ 2.04067990e-11

.Model Wmodel_Trace1879_Auto_2028::MIPI_DSI1_DATA0_P W MODELTYPE=RLGC N=2
+ Lo=
+ 3.30748548e-07
+ 4.21643405e-08 3.30748548e-07
+ Co=
+ 1.03807831e-10
+ -4.52139143e-12 1.03807831e-10
+ Ro=
+ 3.96831067e+00
+ 0.00000000e+00 3.96831067e+00
+ Go=
+ 0.00000000e+00
+ -0.00000000e+00 0.00000000e+00
+ Rs=
+ 1.55902417e-03
+ -0.00000000e+00 1.55902417e-03
+ Gd=
+ 2.03827231e-11
+ -1.75180973e-13 2.03827231e-11

.Model Wmodel_Trace1880::MIPI_DSI1_DATA0_P W MODELTYPE=RLGC N=1
+ Lo=
+ 3.32029740e-07
+ Co=
+ 1.03489020e-10
+ Ro=
+ 3.96831067e+00
+ Go=
+ 0.00000000e+00
+ Rs=
+ 1.55902417e-03
+ Gd=
+ 2.04067990e-11

.Model Wmodel_Trace1880_Auto_1917::MIPI_DSI1_DATA0_P W MODELTYPE=RLGC N=2
+ Lo=
+ 3.31333825e-07
+ 3.25365040e-08 3.31333825e-07
+ Co=
+ 1.03634615e-10
+ -3.02214142e-12 1.03634615e-10
+ Ro=
+ 3.96831067e+00
+ 0.00000000e+00 3.96831067e+00
+ Go=
+ 0.00000000e+00
+ -0.00000000e+00 0.00000000e+00
+ Rs=
+ 1.55902417e-03
+ -0.00000000e+00 1.55902417e-03
+ Gd=
+ 2.03903605e-11
+ -4.22804072e-14 2.03903605e-11

.Model Wmodel_Trace1880_Auto_1918::MIPI_DSI1_DATA0_P W MODELTYPE=RLGC N=1
+ Lo=
+ 3.32029740e-07
+ Co=
+ 1.03489020e-10
+ Ro=
+ 3.96831067e+00
+ Go=
+ 0.00000000e+00
+ Rs=
+ 1.55902417e-03
+ Gd=
+ 2.04067990e-11

.Model Wmodel_Trace1881_Auto_1925::MIPI_DSI1_DATA0_P W MODELTYPE=RLGC N=1
+ Lo=
+ 3.32029740e-07
+ Co=
+ 1.03489020e-10
+ Ro=
+ 3.96831067e+00
+ Go=
+ 0.00000000e+00
+ Rs=
+ 1.55902417e-03
+ Gd=
+ 2.04067990e-11

.Model Wmodel_Trace1885::MIPI_DSI1_DATA0_P W MODELTYPE=RLGC N=1
+ Lo=
+ 3.32029740e-07
+ Co=
+ 1.03489020e-10
+ Ro=
+ 3.96831067e+00
+ Go=
+ 0.00000000e+00
+ Rs=
+ 1.55902417e-03
+ Gd=
+ 2.04067990e-11

.Model Wmodel_Trace1887::MIPI_DSI1_DATA0_P W MODELTYPE=RLGC N=2
+ Lo=
+ 3.30748548e-07
+ 4.21643405e-08 3.30748548e-07
+ Co=
+ 1.03807831e-10
+ -4.52139143e-12 1.03807831e-10
+ Ro=
+ 3.96831067e+00
+ 0.00000000e+00 3.96831067e+00
+ Go=
+ 0.00000000e+00
+ -0.00000000e+00 0.00000000e+00
+ Rs=
+ 1.55902417e-03
+ -0.00000000e+00 1.55902417e-03
+ Gd=
+ 2.03827231e-11
+ -1.75180973e-13 2.03827231e-11

.Model Wmodel_Trace1887_Auto_2047::MIPI_DSI1_DATA0_P W MODELTYPE=RLGC N=2
+ Lo=
+ 3.31006394e-07
+ 3.83409681e-08 3.31006394e-07
+ Co=
+ 1.03727316e-10
+ -3.89420171e-12 1.03727316e-10
+ Ro=
+ 3.96831067e+00
+ 0.00000000e+00 3.96831067e+00
+ Go=
+ 0.00000000e+00
+ -0.00000000e+00 0.00000000e+00
+ Rs=
+ 1.55902417e-03
+ -0.00000000e+00 1.55902417e-03
+ Gd=
+ 2.03853867e-11
+ -1.14974238e-13 2.03853867e-11

.Model Wmodel_Trace1888::MIPI_DSI1_DATA0_P W MODELTYPE=RLGC N=1
+ Lo=
+ 3.32029740e-07
+ Co=
+ 1.03489020e-10
+ Ro=
+ 3.96831067e+00
+ Go=
+ 0.00000000e+00
+ Rs=
+ 1.55902417e-03
+ Gd=
+ 2.04067990e-11

.Model Wmodel_Trace1889::MIPI_DSI1_DATA0_P W MODELTYPE=RLGC N=2
+ Lo=
+ 3.30748548e-07
+ 4.21643405e-08 3.30748548e-07
+ Co=
+ 1.03807831e-10
+ -4.52139143e-12 1.03807831e-10
+ Ro=
+ 3.96831067e+00
+ 0.00000000e+00 3.96831067e+00
+ Go=
+ 0.00000000e+00
+ -0.00000000e+00 0.00000000e+00
+ Rs=
+ 1.55902417e-03
+ -0.00000000e+00 1.55902417e-03
+ Gd=
+ 2.03827231e-11
+ -1.75180973e-13 2.03827231e-11

.Model Wmodel_Trace1891::MIPI_DSI1_DATA0_P W MODELTYPE=RLGC N=1
+ Lo=
+ 3.32029740e-07
+ Co=
+ 1.03489020e-10
+ Ro=
+ 3.96831067e+00
+ Go=
+ 0.00000000e+00
+ Rs=
+ 1.55902417e-03
+ Gd=
+ 2.04067990e-11

.Model Wmodel_Trace1892::MIPI_DSI1_DATA0_P W MODELTYPE=RLGC N=1
+ Lo=
+ 3.32029740e-07
+ Co=
+ 1.03489020e-10
+ Ro=
+ 3.96831067e+00
+ Go=
+ 0.00000000e+00
+ Rs=
+ 1.55902417e-03
+ Gd=
+ 2.04067990e-11

.Model Wmodel_Trace1892_Auto_1945::MIPI_DSI1_DATA0_P W MODELTYPE=RLGC N=1
+ Lo=
+ 3.32029740e-07
+ Co=
+ 1.03489020e-10
+ Ro=
+ 3.96831067e+00
+ Go=
+ 0.00000000e+00
+ Rs=
+ 1.55902417e-03
+ Gd=
+ 2.04067990e-11

.Model Wmodel_Trace1896::MIPI_DSI1_DATA0_P W MODELTYPE=RLGC N=6
+ Lo=
+ 3.57668580e-07
+ 3.74228950e-08 3.56470741e-07
+ 1.17959483e-08 4.60511538e-08 3.56498544e-07
+ 4.88204557e-09 1.13141641e-08 3.52407789e-08 3.56315659e-07
+ 2.90715372e-09 5.40318962e-09 1.16896300e-08 4.87966976e-08 3.56119119e-07
+ 1.86249241e-09 2.99005818e-09 5.17509275e-09 1.29068688e-08 4.09671132e-08 3.57480638e-07
+ Co=
+ 9.38688871e-11
+ -3.05159314e-12 9.41617771e-11
+ -4.60173795e-13 -4.22892584e-12 9.41434569e-11
+ -1.86470502e-13 -4.32929171e-13 -2.77910450e-12 9.42017137e-11
+ -1.07818163e-13 -1.91400973e-13 -4.43080405e-13 -4.63728085e-12 9.42685794e-11
+ -7.28286677e-14 -1.11028918e-13 -1.95935773e-13 -4.92798824e-13 -3.51398321e-12 9.39191009e-11
+ Ro=
+ 4.84133902e+00
+ 0.00000000e+00 4.84133902e+00
+ 0.00000000e+00 0.00000000e+00 4.84133902e+00
+ 0.00000000e+00 0.00000000e+00 0.00000000e+00 4.84133902e+00
+ 0.00000000e+00 0.00000000e+00 0.00000000e+00 0.00000000e+00 4.84133902e+00
+ 0.00000000e+00 0.00000000e+00 0.00000000e+00 0.00000000e+00 0.00000000e+00 4.84133902e+00
+ Go=
+ 0.00000000e+00
+ -0.00000000e+00 0.00000000e+00
+ -0.00000000e+00 -0.00000000e+00 0.00000000e+00
+ -0.00000000e+00 -0.00000000e+00 -0.00000000e+00 0.00000000e+00
+ -0.00000000e+00 -0.00000000e+00 -0.00000000e+00 -0.00000000e+00 0.00000000e+00
+ -0.00000000e+00 -0.00000000e+00 -0.00000000e+00 -0.00000000e+00 -0.00000000e+00 0.00000000e+00
+ Rs=
+ 1.72420198e-03
+ -0.00000000e+00 1.72420198e-03
+ -0.00000000e+00 -0.00000000e+00 1.72420198e-03
+ -0.00000000e+00 -0.00000000e+00 -0.00000000e+00 1.72420198e-03
+ -0.00000000e+00 -0.00000000e+00 -0.00000000e+00 -0.00000000e+00 1.72420198e-03
+ -0.00000000e+00 -0.00000000e+00 -0.00000000e+00 -0.00000000e+00 -0.00000000e+00 1.72420198e-03
+ Gd=
+ 1.82195762e-11
+ -6.68539183e-14 1.81981380e-11
+ -0.00000000e+00 -1.78498833e-13 1.81989669e-11
+ -0.00000000e+00 -0.00000000e+00 -5.21981180e-14 1.81978117e-11
+ -0.00000000e+00 -0.00000000e+00 -0.00000000e+00 -2.21958393e-13 1.81946019e-11
+ -0.00000000e+00 -0.00000000e+00 -0.00000000e+00 -0.00000000e+00 -1.07523796e-13 1.82169544e-11

.Model Wmodel_Trace1897::MIPI_DSI1_DATA0_P W MODELTYPE=RLGC N=6
+ Lo=
+ 3.30910625e-07
+ 3.80595985e-08 3.29223223e-07
+ 1.20044133e-08 4.70545365e-08 3.29269915e-07
+ 4.88487288e-09 1.14672124e-08 3.57015211e-08 3.28996390e-07
+ 2.89494845e-09 5.42813257e-09 1.18684355e-08 4.99486193e-08 3.28705367e-07
+ 1.84889246e-09 2.97971712e-09 5.18962347e-09 1.31900110e-08 4.17447402e-08 3.30637893e-07
+ Co=
+ 1.03735697e-10
+ -3.86024064e-12 1.04193648e-10
+ -5.31335280e-13 -5.41489523e-12 1.04163325e-10
+ -2.15235521e-13 -4.97410906e-13 -3.50121554e-12 1.04259809e-10
+ -1.23895906e-13 -2.18100237e-13 -5.08340698e-13 -5.96330125e-12 1.04367919e-10
+ -8.45431760e-14 -1.27676053e-13 -2.25990285e-13 -5.67092817e-13 -4.46911218e-12 1.03815829e-10
+ Ro=
+ 3.96831067e+00
+ 0.00000000e+00 3.96831067e+00
+ 0.00000000e+00 0.00000000e+00 3.96831067e+00
+ 0.00000000e+00 0.00000000e+00 0.00000000e+00 3.96831067e+00
+ 0.00000000e+00 0.00000000e+00 0.00000000e+00 0.00000000e+00 3.96831067e+00
+ 0.00000000e+00 0.00000000e+00 0.00000000e+00 0.00000000e+00 0.00000000e+00 3.96831067e+00
+ Go=
+ 0.00000000e+00
+ -0.00000000e+00 0.00000000e+00
+ -0.00000000e+00 -0.00000000e+00 0.00000000e+00
+ -0.00000000e+00 -0.00000000e+00 -0.00000000e+00 0.00000000e+00
+ -0.00000000e+00 -0.00000000e+00 -0.00000000e+00 -0.00000000e+00 0.00000000e+00
+ -0.00000000e+00 -0.00000000e+00 -0.00000000e+00 -0.00000000e+00 -0.00000000e+00 0.00000000e+00
+ Rs=
+ 1.55902417e-03
+ -0.00000000e+00 1.55902417e-03
+ -0.00000000e+00 -0.00000000e+00 1.55902417e-03
+ -0.00000000e+00 -0.00000000e+00 -0.00000000e+00 1.55902417e-03
+ -0.00000000e+00 -0.00000000e+00 -0.00000000e+00 -0.00000000e+00 1.55902417e-03
+ -0.00000000e+00 -0.00000000e+00 -0.00000000e+00 -0.00000000e+00 -0.00000000e+00 1.55902417e-03
+ Gd=
+ 2.03844254e-11
+ -1.21491810e-13 2.03593975e-11
+ -0.00000000e+00 -2.84447767e-13 2.03603151e-11
+ -0.00000000e+00 -0.00000000e+00 -9.86900365e-14 2.03602742e-11
+ -0.00000000e+00 -0.00000000e+00 -0.00000000e+00 -3.47973584e-13 2.03569740e-11
+ -0.00000000e+00 -0.00000000e+00 -0.00000000e+00 -0.00000000e+00 -1.81259153e-13 2.03817333e-11

.Model Wmodel_Trace1898::MIPI_DSI1_DATA0_P W MODELTYPE=RLGC N=1
+ Lo=
+ 3.32029740e-07
+ Co=
+ 1.03489020e-10
+ Ro=
+ 3.96831067e+00
+ Go=
+ 0.00000000e+00
+ Rs=
+ 1.55902417e-03
+ Gd=
+ 2.04067990e-11

.Model Wmodel_Trace1899::MIPI_DSI1_DATA0_P W MODELTYPE=RLGC N=6
+ Lo=
+ 3.30651440e-07
+ 4.18202771e-08 3.29165084e-07
+ 1.23552483e-08 4.47367908e-08 3.29452631e-07
+ 4.97776742e-09 1.11364517e-08 3.57266353e-08 3.29000037e-07
+ 2.93622605e-09 5.31704199e-09 1.18768736e-08 4.99498746e-08 3.28705798e-07
+ 1.86912209e-09 2.93466381e-09 5.19314127e-09 1.31905444e-08 4.17449222e-08 3.30637968e-07
+ Co=
+ 1.03815217e-10
+ -4.47874558e-12 1.04206144e-10
+ -5.43501421e-13 -4.99642816e-12 1.04098004e-10
+ -2.16626463e-13 -4.86033992e-13 -3.50474119e-12 1.04259638e-10
+ -1.24261024e-13 -2.14659359e-13 -5.09700701e-13 -5.96335998e-12 1.04367900e-10
+ -8.46042753e-14 -1.26112714e-13 -2.26732821e-13 -5.67122444e-13 -4.46912124e-12 1.03815825e-10
+ Ro=
+ 3.96831067e+00
+ 0.00000000e+00 3.96831067e+00
+ 0.00000000e+00 0.00000000e+00 3.96831067e+00
+ 0.00000000e+00 0.00000000e+00 0.00000000e+00 3.96831067e+00
+ 0.00000000e+00 0.00000000e+00 0.00000000e+00 0.00000000e+00 3.96831067e+00
+ 0.00000000e+00 0.00000000e+00 0.00000000e+00 0.00000000e+00 0.00000000e+00 3.96831067e+00
+ Go=
+ 0.00000000e+00
+ -0.00000000e+00 0.00000000e+00
+ -0.00000000e+00 -0.00000000e+00 0.00000000e+00
+ -0.00000000e+00 -0.00000000e+00 -0.00000000e+00 0.00000000e+00
+ -0.00000000e+00 -0.00000000e+00 -0.00000000e+00 -0.00000000e+00 0.00000000e+00
+ -0.00000000e+00 -0.00000000e+00 -0.00000000e+00 -0.00000000e+00 -0.00000000e+00 0.00000000e+00
+ Rs=
+ 1.55902417e-03
+ -0.00000000e+00 1.55902417e-03
+ -0.00000000e+00 -0.00000000e+00 1.55902417e-03
+ -0.00000000e+00 -0.00000000e+00 -0.00000000e+00 1.55902417e-03
+ -0.00000000e+00 -0.00000000e+00 -0.00000000e+00 -0.00000000e+00 1.55902417e-03
+ -0.00000000e+00 -0.00000000e+00 -0.00000000e+00 -0.00000000e+00 -0.00000000e+00 1.55902417e-03
+ Gd=
+ 2.03817901e-11
+ -1.80594337e-13 2.03575549e-11
+ -0.00000000e+00 -2.39854595e-13 2.03608646e-11
+ -0.00000000e+00 -0.00000000e+00 -9.84453450e-14 2.03602901e-11
+ -0.00000000e+00 -0.00000000e+00 -0.00000000e+00 -3.47968303e-13 2.03569756e-11
+ -0.00000000e+00 -0.00000000e+00 -0.00000000e+00 -0.00000000e+00 -1.81258305e-13 2.03817337e-11

.Model Wmodel_Trace1900::MIPI_DSI1_DATA0_P W MODELTYPE=RLGC N=6
+ Lo=
+ 3.30588227e-07
+ 4.21052915e-08 3.28179527e-07
+ 1.39598092e-08 5.44587893e-08 3.28115481e-07
+ 5.70855331e-09 1.36788789e-08 4.11508947e-08 3.27980932e-07
+ 3.36441375e-09 6.41271306e-09 1.38740068e-08 5.57328511e-08 3.28071893e-07
+ 2.07615340e-09 3.35198049e-09 5.73414557e-09 1.40533301e-08 4.16405698e-08 3.30619069e-07
+ Co=
+ 1.03827100e-10
+ -4.53517585e-12 1.04557567e-10
+ -5.83955201e-13 -6.86665984e-12 1.04552827e-10
+ -2.39310987e-13 -5.55609918e-13 -4.39632826e-12 1.04607839e-10
+ -1.38180842e-13 -2.41331523e-13 -5.61269309e-13 -7.12796831e-12 1.04602393e-10
+ -9.32234104e-14 -1.38345535e-13 -2.41013675e-13 -5.85712499e-13 -4.45678721e-12 1.03816595e-10
+ Ro=
+ 3.96831067e+00
+ 0.00000000e+00 3.96831067e+00
+ 0.00000000e+00 0.00000000e+00 3.96831067e+00
+ 0.00000000e+00 0.00000000e+00 0.00000000e+00 3.96831067e+00
+ 0.00000000e+00 0.00000000e+00 0.00000000e+00 0.00000000e+00 3.96831067e+00
+ 0.00000000e+00 0.00000000e+00 0.00000000e+00 0.00000000e+00 0.00000000e+00 3.96831067e+00
+ Go=
+ 0.00000000e+00
+ -0.00000000e+00 0.00000000e+00
+ -0.00000000e+00 -0.00000000e+00 0.00000000e+00
+ -0.00000000e+00 -0.00000000e+00 -0.00000000e+00 0.00000000e+00
+ -0.00000000e+00 -0.00000000e+00 -0.00000000e+00 -0.00000000e+00 0.00000000e+00
+ -0.00000000e+00 -0.00000000e+00 -0.00000000e+00 -0.00000000e+00 -0.00000000e+00 0.00000000e+00
+ Rs=
+ 1.55902417e-03
+ -0.00000000e+00 1.55902417e-03
+ -0.00000000e+00 -0.00000000e+00 1.55902417e-03
+ -0.00000000e+00 -0.00000000e+00 -0.00000000e+00 1.55902417e-03
+ -0.00000000e+00 -0.00000000e+00 -0.00000000e+00 -0.00000000e+00 1.55902417e-03
+ -0.00000000e+00 -0.00000000e+00 -0.00000000e+00 -0.00000000e+00 -0.00000000e+00 1.55902417e-03
+ Gd=
+ 2.03814071e-11
+ -1.89522853e-13 2.03587023e-11
+ -0.00000000e+00 -4.57877070e-13 2.03582732e-11
+ -0.00000000e+00 -0.00000000e+00 -1.87553554e-13 2.03593718e-11
+ -0.00000000e+00 -0.00000000e+00 -0.00000000e+00 -4.89825579e-13 2.03600170e-11
+ -0.00000000e+00 -0.00000000e+00 -0.00000000e+00 -0.00000000e+00 -1.81972190e-13 2.03816643e-11

.Model Wmodel_Trace1902::MIPI_DSI1_DATA0_P W MODELTYPE=RLGC N=1
+ Lo=
+ 3.32029740e-07
+ Co=
+ 1.03489020e-10
+ Ro=
+ 3.96831067e+00
+ Go=
+ 0.00000000e+00
+ Rs=
+ 1.55902417e-03
+ Gd=
+ 2.04067990e-11

.Model Wmodel_Trace1904::MIPI_DSI1_DATA0_P W MODELTYPE=RLGC N=2
+ Lo=
+ 3.30748904e-07
+ 4.21593990e-08 3.30748904e-07
+ Co=
+ 1.03807716e-10
+ -4.52055469e-12 1.03807716e-10
+ Ro=
+ 3.96831067e+00
+ 0.00000000e+00 3.96831067e+00
+ Go=
+ 0.00000000e+00
+ -0.00000000e+00 0.00000000e+00
+ Rs=
+ 1.55902417e-03
+ -0.00000000e+00 1.55902417e-03
+ Gd=
+ 2.03827260e-11
+ -1.75097034e-13 2.03827260e-11

.Model Wmodel_Trace1904_Auto_737::MIPI_DSI1_DATA0_P W MODELTYPE=RLGC N=1
+ Lo=
+ 3.32029740e-07
+ Co=
+ 1.03489020e-10
+ Ro=
+ 3.96831067e+00
+ Go=
+ 0.00000000e+00
+ Rs=
+ 1.55902417e-03
+ Gd=
+ 2.04067990e-11

.Model Wmodel_Trace1908::MIPI_DSI1_DATA0_P W MODELTYPE=RLGC N=1
+ Lo=
+ 3.32029740e-07
+ Co=
+ 1.03489020e-10
+ Ro=
+ 3.96831067e+00
+ Go=
+ 0.00000000e+00
+ Rs=
+ 1.55902417e-03
+ Gd=
+ 2.04067990e-11

.Model Wmodel_Trace1910::MIPI_DSI1_DATA0_P W MODELTYPE=RLGC N=1
+ Lo=
+ 3.32029740e-07
+ Co=
+ 1.03489020e-10
+ Ro=
+ 3.96831067e+00
+ Go=
+ 0.00000000e+00
+ Rs=
+ 1.55902417e-03
+ Gd=
+ 2.04067990e-11

.Model Wmodel_Trace1910_Auto_325::MIPI_DSI1_DATA0_P W MODELTYPE=RLGC N=1
+ Lo=
+ 3.32029740e-07
+ Co=
+ 1.03489020e-10
+ Ro=
+ 3.96831067e+00
+ Go=
+ 0.00000000e+00
+ Rs=
+ 1.55902417e-03
+ Gd=
+ 2.04067990e-11

.Model Wmodel_Trace1919::MIPI_DSI1_DATA0_P W MODELTYPE=RLGC N=1
+ Lo=
+ 3.32029740e-07
+ Co=
+ 1.03489020e-10
+ Ro=
+ 3.96831067e+00
+ Go=
+ 0.00000000e+00
+ Rs=
+ 1.55902417e-03
+ Gd=
+ 2.04067990e-11

.Model Wmodel_Trace1921::MIPI_DSI1_DATA0_P W MODELTYPE=RLGC N=1
+ Lo=
+ 3.32029740e-07
+ Co=
+ 1.03489020e-10
+ Ro=
+ 3.96831067e+00
+ Go=
+ 0.00000000e+00
+ Rs=
+ 1.55902417e-03
+ Gd=
+ 2.04067990e-11

.Model Wmodel_Trace1921_Auto_328::MIPI_DSI1_DATA0_P W MODELTYPE=RLGC N=1
+ Lo=
+ 3.32029740e-07
+ Co=
+ 1.03489020e-10
+ Ro=
+ 3.96831067e+00
+ Go=
+ 0.00000000e+00
+ Rs=
+ 1.55902417e-03
+ Gd=
+ 2.04067990e-11

.Model Wmodel_Trace1924::MIPI_DSI1_DATA0_P W MODELTYPE=RLGC N=1
+ Lo=
+ 3.32029740e-07
+ Co=
+ 1.03489020e-10
+ Ro=
+ 3.96831067e+00
+ Go=
+ 0.00000000e+00
+ Rs=
+ 1.55902417e-03
+ Gd=
+ 2.04067990e-11

.Model Wmodel_Trace1926::MIPI_DSI1_DATA0_P W MODELTYPE=RLGC N=1
+ Lo=
+ 3.32029740e-07
+ Co=
+ 1.03489020e-10
+ Ro=
+ 3.96831067e+00
+ Go=
+ 0.00000000e+00
+ Rs=
+ 1.55902417e-03
+ Gd=
+ 2.04067990e-11

.Model Wmodel_Trace1926_Auto_310::MIPI_DSI1_DATA0_P W MODELTYPE=RLGC N=2
+ Lo=
+ 3.30748904e-07
+ 4.21593990e-08 3.30748904e-07
+ Co=
+ 1.03807716e-10
+ -4.52055469e-12 1.03807716e-10
+ Ro=
+ 3.96831067e+00
+ 0.00000000e+00 3.96831067e+00
+ Go=
+ 0.00000000e+00
+ -0.00000000e+00 0.00000000e+00
+ Rs=
+ 1.55902417e-03
+ -0.00000000e+00 1.55902417e-03
+ Gd=
+ 2.03827260e-11
+ -1.75097034e-13 2.03827260e-11

.Model Wmodel_Trace1926_Auto_311::MIPI_DSI1_DATA0_P W MODELTYPE=RLGC N=1
+ Lo=
+ 3.32029740e-07
+ Co=
+ 1.03489020e-10
+ Ro=
+ 3.96831067e+00
+ Go=
+ 0.00000000e+00
+ Rs=
+ 1.55902417e-03
+ Gd=
+ 2.04067990e-11

.Model Wmodel_Trace1930::MIPI_DSI1_DATA0_P W MODELTYPE=RLGC N=1
+ Lo=
+ 3.32029740e-07
+ Co=
+ 1.03489020e-10
+ Ro=
+ 3.96831067e+00
+ Go=
+ 0.00000000e+00
+ Rs=
+ 1.55902417e-03
+ Gd=
+ 2.04067990e-11

.Model Wmodel_Trace1932::MIPI_DSI1_DATA0_P W MODELTYPE=RLGC N=1
+ Lo=
+ 3.32029740e-07
+ Co=
+ 1.03489020e-10
+ Ro=
+ 3.96831067e+00
+ Go=
+ 0.00000000e+00
+ Rs=
+ 1.55902417e-03
+ Gd=
+ 2.04067990e-11

.Model Wmodel_Trace1932_Auto_316::MIPI_DSI1_DATA0_P W MODELTYPE=RLGC N=1
+ Lo=
+ 3.32029740e-07
+ Co=
+ 1.03489020e-10
+ Ro=
+ 3.96831067e+00
+ Go=
+ 0.00000000e+00
+ Rs=
+ 1.55902417e-03
+ Gd=
+ 2.04067990e-11

.Model Wmodel_Trace1941::MIPI_DSI1_DATA0_P W MODELTYPE=RLGC N=1
+ Lo=
+ 3.32029740e-07
+ Co=
+ 1.03489020e-10
+ Ro=
+ 3.96831067e+00
+ Go=
+ 0.00000000e+00
+ Rs=
+ 1.55902417e-03
+ Gd=
+ 2.04067990e-11

.Model Wmodel_Trace1943::MIPI_DSI1_DATA0_P W MODELTYPE=RLGC N=1
+ Lo=
+ 3.32029740e-07
+ Co=
+ 1.03489020e-10
+ Ro=
+ 3.96831067e+00
+ Go=
+ 0.00000000e+00
+ Rs=
+ 1.55902417e-03
+ Gd=
+ 2.04067990e-11

.Model Wmodel_Trace1943_Auto_319::MIPI_DSI1_DATA0_P W MODELTYPE=RLGC N=1
+ Lo=
+ 3.32029740e-07
+ Co=
+ 1.03489020e-10
+ Ro=
+ 3.96831067e+00
+ Go=
+ 0.00000000e+00
+ Rs=
+ 1.55902417e-03
+ Gd=
+ 2.04067990e-11

.Model Wmodel_Trace1946::MIPI_DSI1_DATA0_P W MODELTYPE=RLGC N=1
+ Lo=
+ 3.32029740e-07
+ Co=
+ 1.03489020e-10
+ Ro=
+ 3.96831067e+00
+ Go=
+ 0.00000000e+00
+ Rs=
+ 1.55902417e-03
+ Gd=
+ 2.04067990e-11

.Model Wmodel_Trace1948::MIPI_DSI1_DATA0_P W MODELTYPE=RLGC N=1
+ Lo=
+ 3.32029740e-07
+ Co=
+ 1.03489020e-10
+ Ro=
+ 3.96831067e+00
+ Go=
+ 0.00000000e+00
+ Rs=
+ 1.55902417e-03
+ Gd=
+ 2.04067990e-11

.Model Wmodel_Trace1948_Auto_372::MIPI_DSI1_DATA0_P W MODELTYPE=RLGC N=2
+ Lo=
+ 3.30812642e-07
+ 4.12604102e-08 3.30812641e-07
+ Co=
+ 1.03787262e-10
+ -4.36944504e-12 1.03787262e-10
+ Ro=
+ 3.96831067e+00
+ 0.00000000e+00 3.96831067e+00
+ Go=
+ 0.00000000e+00
+ -0.00000000e+00 0.00000000e+00
+ Rs=
+ 1.55902417e-03
+ -0.00000000e+00 1.55902417e-03
+ Gd=
+ 2.03832868e-11
+ -1.60087502e-13 2.03832868e-11

.Model Wmodel_Trace1952::MIPI_DSI1_DATA0_P W MODELTYPE=RLGC N=1
+ Lo=
+ 3.32029740e-07
+ Co=
+ 1.03489020e-10
+ Ro=
+ 3.96831067e+00
+ Go=
+ 0.00000000e+00
+ Rs=
+ 1.55902417e-03
+ Gd=
+ 2.04067990e-11

.Model Wmodel_Trace1954::MIPI_DSI1_DATA0_P W MODELTYPE=RLGC N=1
+ Lo=
+ 3.32029740e-07
+ Co=
+ 1.03489020e-10
+ Ro=
+ 3.96831067e+00
+ Go=
+ 0.00000000e+00
+ Rs=
+ 1.55902417e-03
+ Gd=
+ 2.04067990e-11

.Model Wmodel_Trace1954_Auto_360::MIPI_DSI1_DATA0_P W MODELTYPE=RLGC N=1
+ Lo=
+ 3.32029740e-07
+ Co=
+ 1.03489020e-10
+ Ro=
+ 3.96831067e+00
+ Go=
+ 0.00000000e+00
+ Rs=
+ 1.55902417e-03
+ Gd=
+ 2.04067990e-11

.Model Wmodel_Trace1963::MIPI_DSI1_DATA0_P W MODELTYPE=RLGC N=1
+ Lo=
+ 3.32029740e-07
+ Co=
+ 1.03489020e-10
+ Ro=
+ 3.96831067e+00
+ Go=
+ 0.00000000e+00
+ Rs=
+ 1.55902417e-03
+ Gd=
+ 2.04067990e-11

.Model Wmodel_Trace1965::MIPI_DSI1_DATA0_P W MODELTYPE=RLGC N=2
+ Lo=
+ 3.30767852e-07
+ 4.18949879e-08 3.30767852e-07
+ Co=
+ 1.03801599e-10
+ -4.47588018e-12 1.03801599e-10
+ Ro=
+ 3.96831067e+00
+ 0.00000000e+00 3.96831067e+00
+ Go=
+ 0.00000000e+00
+ -0.00000000e+00 0.00000000e+00
+ Rs=
+ 1.55902417e-03
+ -0.00000000e+00 1.55902417e-03
+ Gd=
+ 2.03828862e-11
+ -1.70628493e-13 2.03828862e-11

.Model Wmodel_Trace1969::MIPI_DSI1_DATA0_P W MODELTYPE=RLGC N=1
+ Lo=
+ 3.32029740e-07
+ Co=
+ 1.03489020e-10
+ Ro=
+ 3.96831067e+00
+ Go=
+ 0.00000000e+00
+ Rs=
+ 1.55902417e-03
+ Gd=
+ 2.04067990e-11

.Model Wmodel_Trace1971::MIPI_DSI1_DATA0_P W MODELTYPE=RLGC N=2
+ Lo=
+ 3.30815830e-07
+ 4.12147002e-08 3.30815830e-07
+ Co=
+ 1.03786248e-10
+ -4.36182104e-12 1.03786248e-10
+ Ro=
+ 3.96831067e+00
+ 0.00000000e+00 3.96831067e+00
+ Go=
+ 0.00000000e+00
+ -0.00000000e+00 0.00000000e+00
+ Rs=
+ 1.55902417e-03
+ -0.00000000e+00 1.55902417e-03
+ Gd=
+ 2.03833165e-11
+ -1.59338240e-13 2.03833165e-11

.Model Wmodel_Trace1972#BP0::MIPI_DSI1_DATA0_P W MODELTYPE=RLGC N=2
+ Lo=
+ 3.31141551e-07
+ 3.61029539e-08 3.31141551e-07
+ Co=
+ 1.03687645e-10
+ -3.54627070e-12 1.03687645e-10
+ Ro=
+ 3.96831067e+00
+ 0.00000000e+00 3.96831067e+00
+ Go=
+ 0.00000000e+00
+ -0.00000000e+00 0.00000000e+00
+ Rs=
+ 1.55902417e-03
+ -0.00000000e+00 1.55902417e-03
+ Gd=
+ 2.03872168e-11
+ -8.42269567e-14 2.03872168e-11

.Model Wmodel_Trace1973::MIPI_DSI1_DATA0_P W MODELTYPE=RLGC N=1
+ Lo=
+ 3.32029740e-07
+ Co=
+ 1.03489020e-10
+ Ro=
+ 3.96831067e+00
+ Go=
+ 0.00000000e+00
+ Rs=
+ 1.55902417e-03
+ Gd=
+ 2.04067990e-11

.Model Wmodel_Trace551::MIPI_DSI1_CLK_N W MODELTYPE=RLGC N=1
+ Lo=
+ 3.32029740e-07
+ Co=
+ 1.03489020e-10
+ Ro=
+ 3.96831067e+00
+ Go=
+ 0.00000000e+00
+ Rs=
+ 1.55902417e-03
+ Gd=
+ 2.04067990e-11

.Model Wmodel_Trace553::MIPI_DSI1_CLK_N W MODELTYPE=RLGC N=2
+ Lo=
+ 3.30769440e-07
+ 4.18727259e-08 3.30769440e-07
+ Co=
+ 1.03801088e-10
+ -4.47212757e-12 1.03801088e-10
+ Ro=
+ 3.96831067e+00
+ 0.00000000e+00 3.96831067e+00
+ Go=
+ 0.00000000e+00
+ -0.00000000e+00 0.00000000e+00
+ Rs=
+ 1.55902417e-03
+ -0.00000000e+00 1.55902417e-03
+ Gd=
+ 2.03828998e-11
+ -1.70254314e-13 2.03828998e-11

.Model Wmodel_Trace555::MIPI_DSI1_CLK_N W MODELTYPE=RLGC N=1
+ Lo=
+ 3.32029740e-07
+ Co=
+ 1.03489020e-10
+ Ro=
+ 3.96831067e+00
+ Go=
+ 0.00000000e+00
+ Rs=
+ 1.55902417e-03
+ Gd=
+ 2.04067990e-11

.Model Wmodel_Trace557::MIPI_DSI1_CLK_N W MODELTYPE=RLGC N=1
+ Lo=
+ 3.32029740e-07
+ Co=
+ 1.03489020e-10
+ Ro=
+ 3.96831067e+00
+ Go=
+ 0.00000000e+00
+ Rs=
+ 1.55902417e-03
+ Gd=
+ 2.04067990e-11

.Model Wmodel_Trace557_Auto_389::MIPI_DSI1_CLK_N W MODELTYPE=RLGC N=2
+ Lo=
+ 3.30706772e-07
+ 4.27390456e-08 3.30706772e-07
+ Co=
+ 1.03821424e-10
+ -4.61915822e-12 1.03821424e-10
+ Ro=
+ 3.96831067e+00
+ 0.00000000e+00 3.96831067e+00
+ Go=
+ 0.00000000e+00
+ -0.00000000e+00 0.00000000e+00
+ Rs=
+ 1.55902417e-03
+ -0.00000000e+00 1.55902417e-03
+ Gd=
+ 2.03823897e-11
+ -1.85049413e-13 2.03823897e-11

.Model Wmodel_Trace557_Auto_390::MIPI_DSI1_CLK_N W MODELTYPE=RLGC N=1
+ Lo=
+ 3.32029740e-07
+ Co=
+ 1.03489020e-10
+ Ro=
+ 3.96831067e+00
+ Go=
+ 0.00000000e+00
+ Rs=
+ 1.55902417e-03
+ Gd=
+ 2.04067990e-11

.Model Wmodel_Trace559::MIPI_DSI1_CLK_N W MODELTYPE=RLGC N=1
+ Lo=
+ 3.32029740e-07
+ Co=
+ 1.03489020e-10
+ Ro=
+ 3.96831067e+00
+ Go=
+ 0.00000000e+00
+ Rs=
+ 1.55902417e-03
+ Gd=
+ 2.04067990e-11

.Model Wmodel_Trace561::MIPI_DSI1_CLK_N W MODELTYPE=RLGC N=1
+ Lo=
+ 3.32029740e-07
+ Co=
+ 1.03489020e-10
+ Ro=
+ 3.96831067e+00
+ Go=
+ 0.00000000e+00
+ Rs=
+ 1.55902417e-03
+ Gd=
+ 2.04067990e-11

.Model Wmodel_Trace561_Auto_387::MIPI_DSI1_CLK_N W MODELTYPE=RLGC N=2
+ Lo=
+ 3.30740670e-07
+ 4.22735563e-08 3.30740670e-07
+ Co=
+ 1.03810383e-10
+ -4.53990158e-12 1.03810383e-10
+ Ro=
+ 3.96831067e+00
+ 0.00000000e+00 3.96831067e+00
+ Go=
+ 0.00000000e+00
+ -0.00000000e+00 0.00000000e+00
+ Rs=
+ 1.55902417e-03
+ -0.00000000e+00 1.55902417e-03
+ Gd=
+ 2.03826582e-11
+ -1.77040127e-13 2.03826582e-11

.Model Wmodel_Trace562::MIPI_DSI1_CLK_N W MODELTYPE=RLGC N=1
+ Lo=
+ 3.32029740e-07
+ Co=
+ 1.03489020e-10
+ Ro=
+ 3.96831067e+00
+ Go=
+ 0.00000000e+00
+ Rs=
+ 1.55902417e-03
+ Gd=
+ 2.04067990e-11

.Model Wmodel_Trace573::MIPI_DSI1_CLK_N W MODELTYPE=RLGC N=1
+ Lo=
+ 3.32029740e-07
+ Co=
+ 1.03489020e-10
+ Ro=
+ 3.96831067e+00
+ Go=
+ 0.00000000e+00
+ Rs=
+ 1.55902417e-03
+ Gd=
+ 2.04067990e-11

.Model Wmodel_Trace574_Auto_400::MIPI_DSI1_CLK_N W MODELTYPE=RLGC N=1
+ Lo=
+ 3.32029740e-07
+ Co=
+ 1.03489020e-10
+ Ro=
+ 3.96831067e+00
+ Go=
+ 0.00000000e+00
+ Rs=
+ 1.55902417e-03
+ Gd=
+ 2.04067990e-11

.Model Wmodel_Trace575::MIPI_DSI1_CLK_N W MODELTYPE=RLGC N=1
+ Lo=
+ 3.32029740e-07
+ Co=
+ 1.03489020e-10
+ Ro=
+ 3.96831067e+00
+ Go=
+ 0.00000000e+00
+ Rs=
+ 1.55902417e-03
+ Gd=
+ 2.04067990e-11

.Model Wmodel_Trace584::MIPI_DSI1_CLK_N W MODELTYPE=RLGC N=1
+ Lo=
+ 3.32029740e-07
+ Co=
+ 1.03489020e-10
+ Ro=
+ 3.96831067e+00
+ Go=
+ 0.00000000e+00
+ Rs=
+ 1.55902417e-03
+ Gd=
+ 2.04067990e-11

.Model Wmodel_Trace586::MIPI_DSI1_CLK_N W MODELTYPE=RLGC N=1
+ Lo=
+ 3.32029740e-07
+ Co=
+ 1.03489020e-10
+ Ro=
+ 3.96831067e+00
+ Go=
+ 0.00000000e+00
+ Rs=
+ 1.55902417e-03
+ Gd=
+ 2.04067990e-11

.Model Wmodel_Trace586_Auto_417::MIPI_DSI1_CLK_N W MODELTYPE=RLGC N=3
+ Lo=
+ 3.30051172e-07
+ 4.92950423e-08 3.28847903e-07
+ 1.32455837e-08 4.22520519e-08 3.30622881e-07
+ Co=
+ 1.04024123e-10
+ -5.81762043e-12 1.04340865e-10
+ -5.80432408e-13 -4.55150632e-12 1.03825169e-10
+ Ro=
+ 3.96831067e+00
+ 0.00000000e+00 3.96831067e+00
+ 0.00000000e+00 0.00000000e+00 3.96831067e+00
+ Go=
+ 0.00000000e+00
+ -0.00000000e+00 0.00000000e+00
+ -0.00000000e+00 -0.00000000e+00 0.00000000e+00
+ Rs=
+ 1.55902417e-03
+ -0.00000000e+00 1.55902417e-03
+ -0.00000000e+00 -0.00000000e+00 1.55902417e-03
+ Gd=
+ 2.03795689e-11
+ -3.23777119e-13 2.03574155e-11
+ -0.00000000e+00 -1.88634064e-13 2.03816676e-11

.Model Wmodel_Trace588::MIPI_DSI1_CLK_N W MODELTYPE=RLGC N=1
+ Lo=
+ 3.32029740e-07
+ Co=
+ 1.03489020e-10
+ Ro=
+ 3.96831067e+00
+ Go=
+ 0.00000000e+00
+ Rs=
+ 1.55902417e-03
+ Gd=
+ 2.04067990e-11

.Model Wmodel_Trace598::MIPI_DSI1_CLK_N W MODELTYPE=RLGC N=1
+ Lo=
+ 3.32029740e-07
+ Co=
+ 1.03489020e-10
+ Ro=
+ 3.96831067e+00
+ Go=
+ 0.00000000e+00
+ Rs=
+ 1.55902417e-03
+ Gd=
+ 2.04067990e-11

.Model Wmodel_Trace598_Auto_397::MIPI_DSI1_CLK_N W MODELTYPE=RLGC N=6
+ Lo=
+ 3.30643730e-07
+ 4.17347530e-08 3.28872565e-07
+ 1.28495267e-08 4.79049181e-08 3.28801546e-07
+ 5.43634676e-09 1.27297133e-08 4.13976409e-08 3.29106843e-07
+ 3.02468757e-09 5.54225181e-09 1.21232839e-08 4.42253444e-08 3.29186411e-07
+ 1.91391537e-09 3.02619920e-09 5.26690611e-09 1.22563423e-08 4.18033931e-08 3.30652097e-07
+ Co=
+ 1.03814916e-10
+ -4.46678859e-12 1.04302266e-10
+ -5.54751008e-13 -5.58065521e-12 1.04307032e-10
+ -2.32517705e-13 -5.37879616e-13 -4.42489599e-12 1.04199512e-10
+ -1.29862699e-13 -2.24678137e-13 -5.18671026e-13 -4.90929349e-12 1.04194653e-10
+ -8.65451449e-14 -1.28525421e-13 -2.24836630e-13 -5.37684382e-13 -4.47622161e-12 1.03814850e-10
+ Ro=
+ 3.96831067e+00
+ 0.00000000e+00 3.96831067e+00
+ 0.00000000e+00 0.00000000e+00 3.96831067e+00
+ 0.00000000e+00 0.00000000e+00 0.00000000e+00 3.96831067e+00
+ 0.00000000e+00 0.00000000e+00 0.00000000e+00 0.00000000e+00 3.96831067e+00
+ 0.00000000e+00 0.00000000e+00 0.00000000e+00 0.00000000e+00 0.00000000e+00 3.96831067e+00
+ Go=
+ 0.00000000e+00
+ -0.00000000e+00 0.00000000e+00
+ -0.00000000e+00 -0.00000000e+00 0.00000000e+00
+ -0.00000000e+00 -0.00000000e+00 -0.00000000e+00 0.00000000e+00
+ -0.00000000e+00 -0.00000000e+00 -0.00000000e+00 -0.00000000e+00 0.00000000e+00
+ -0.00000000e+00 -0.00000000e+00 -0.00000000e+00 -0.00000000e+00 -0.00000000e+00 0.00000000e+00
+ Rs=
+ 1.55902417e-03
+ -0.00000000e+00 1.55902417e-03
+ -0.00000000e+00 -0.00000000e+00 1.55902417e-03
+ -0.00000000e+00 -0.00000000e+00 -0.00000000e+00 1.55902417e-03
+ -0.00000000e+00 -0.00000000e+00 -0.00000000e+00 -0.00000000e+00 1.55902417e-03
+ -0.00000000e+00 -0.00000000e+00 -0.00000000e+00 -0.00000000e+00 -0.00000000e+00 1.55902417e-03
+ Gd=
+ 2.03817632e-11
+ -1.80464915e-13 2.03568153e-11
+ -0.00000000e+00 -3.06021805e-13 2.03562205e-11
+ -0.00000000e+00 -0.00000000e+00 -1.85001901e-13 2.03570175e-11
+ -0.00000000e+00 -0.00000000e+00 -0.00000000e+00 -2.32276952e-13 2.03576494e-11
+ -0.00000000e+00 -0.00000000e+00 -0.00000000e+00 -0.00000000e+00 -1.80262204e-13 2.03817954e-11

.Model Wmodel_Trace598_Auto_409::MIPI_DSI1_CLK_N W MODELTYPE=RLGC N=1
+ Lo=
+ 3.32029740e-07
+ Co=
+ 1.03489020e-10
+ Ro=
+ 3.96831067e+00
+ Go=
+ 0.00000000e+00
+ Rs=
+ 1.55902417e-03
+ Gd=
+ 2.04067990e-11

.Model Wmodel_Trace598_Auto_424::MIPI_DSI1_CLK_N W MODELTYPE=RLGC N=6
+ Lo=
+ 3.30643488e-07
+ 4.17342228e-08 3.28871397e-07
+ 1.28480676e-08 4.79016496e-08 3.28792142e-07
+ 5.42901949e-09 1.27125481e-08 4.13454113e-08 3.28791072e-07
+ 3.09565423e-09 5.72450160e-09 1.27143327e-08 4.79128662e-08 3.28868743e-07
+ 1.94832121e-09 3.09618013e-09 5.43074504e-09 1.28542441e-08 4.17566342e-08 3.30641747e-07
+ Co=
+ 1.03814929e-10
+ -4.46676253e-12 1.04302318e-10
+ -5.54673983e-13 -5.58050682e-12 1.04307444e-10
+ -2.31190316e-13 -5.35416287e-13 -4.41839199e-12 1.04307814e-10
+ -1.31245594e-13 -2.28669485e-13 -5.35458306e-13 -5.58262847e-12 1.04303209e-10
+ -8.79903859e-14 -1.31271440e-13 -2.31244883e-13 -5.54857649e-13 -4.47057981e-12 1.03815463e-10
+ Ro=
+ 3.96831067e+00
+ 0.00000000e+00 3.96831067e+00
+ 0.00000000e+00 0.00000000e+00 3.96831067e+00
+ 0.00000000e+00 0.00000000e+00 0.00000000e+00 3.96831067e+00
+ 0.00000000e+00 0.00000000e+00 0.00000000e+00 0.00000000e+00 3.96831067e+00
+ 0.00000000e+00 0.00000000e+00 0.00000000e+00 0.00000000e+00 0.00000000e+00 3.96831067e+00
+ Go=
+ 0.00000000e+00
+ -0.00000000e+00 0.00000000e+00
+ -0.00000000e+00 -0.00000000e+00 0.00000000e+00
+ -0.00000000e+00 -0.00000000e+00 -0.00000000e+00 0.00000000e+00
+ -0.00000000e+00 -0.00000000e+00 -0.00000000e+00 -0.00000000e+00 0.00000000e+00
+ -0.00000000e+00 -0.00000000e+00 -0.00000000e+00 -0.00000000e+00 -0.00000000e+00 0.00000000e+00
+ Rs=
+ 1.55902417e-03
+ -0.00000000e+00 1.55902417e-03
+ -0.00000000e+00 -0.00000000e+00 1.55902417e-03
+ -0.00000000e+00 -0.00000000e+00 -0.00000000e+00 1.55902417e-03
+ -0.00000000e+00 -0.00000000e+00 -0.00000000e+00 -0.00000000e+00 1.55902417e-03
+ -0.00000000e+00 -0.00000000e+00 -0.00000000e+00 -0.00000000e+00 -0.00000000e+00 1.55902417e-03
+ Gd=
+ 2.03817622e-11
+ -1.80467059e-13 2.03568111e-11
+ -0.00000000e+00 -3.06034371e-13 2.03561844e-11
+ -0.00000000e+00 -0.00000000e+00 -1.85444628e-13 2.03561837e-11
+ -0.00000000e+00 -0.00000000e+00 -0.00000000e+00 -3.06281413e-13 2.03567981e-11
+ -0.00000000e+00 -0.00000000e+00 -0.00000000e+00 -0.00000000e+00 -1.80855679e-13 2.03817481e-11

.Model Wmodel_Trace598_Auto_432::MIPI_DSI1_CLK_N W MODELTYPE=RLGC N=6
+ Lo=
+ 3.30643914e-07
+ 4.17351503e-08 3.28873429e-07
+ 1.28505999e-08 4.79072865e-08 3.28808209e-07
+ 5.44156052e-09 1.27417077e-08 4.14332260e-08 3.29313107e-07
+ 2.97007364e-09 5.40378599e-09 1.16824989e-08 4.15656710e-08 3.29393731e-07
+ 1.88716826e-09 2.97220243e-09 5.14192557e-09 1.18113728e-08 4.18397736e-08 3.30659094e-07
+ Co=
+ 1.03814906e-10
+ -4.46680932e-12 1.04302226e-10
+ -5.54810905e-13 -5.58076943e-12 1.04306720e-10
+ -2.33452881e-13 -5.39603087e-13 -4.42937352e-12 1.04132784e-10
+ -1.28670321e-13 -2.21384454e-13 -5.05412495e-13 -4.44647477e-12 1.04127848e-10
+ -8.54187394e-14 -1.26400447e-13 -2.19923440e-13 -5.24142468e-13 -4.48088024e-12 1.03814502e-10
+ Ro=
+ 3.96831067e+00
+ 0.00000000e+00 3.96831067e+00
+ 0.00000000e+00 0.00000000e+00 3.96831067e+00
+ 0.00000000e+00 0.00000000e+00 0.00000000e+00 3.96831067e+00
+ 0.00000000e+00 0.00000000e+00 0.00000000e+00 0.00000000e+00 3.96831067e+00
+ 0.00000000e+00 0.00000000e+00 0.00000000e+00 0.00000000e+00 0.00000000e+00 3.96831067e+00
+ Go=
+ 0.00000000e+00
+ -0.00000000e+00 0.00000000e+00
+ -0.00000000e+00 -0.00000000e+00 0.00000000e+00
+ -0.00000000e+00 -0.00000000e+00 -0.00000000e+00 0.00000000e+00
+ -0.00000000e+00 -0.00000000e+00 -0.00000000e+00 -0.00000000e+00 0.00000000e+00
+ -0.00000000e+00 -0.00000000e+00 -0.00000000e+00 -0.00000000e+00 -0.00000000e+00 0.00000000e+00
+ Rs=
+ 1.55902417e-03
+ -0.00000000e+00 1.55902417e-03
+ -0.00000000e+00 -0.00000000e+00 1.55902417e-03
+ -0.00000000e+00 -0.00000000e+00 -0.00000000e+00 1.55902417e-03
+ -0.00000000e+00 -0.00000000e+00 -0.00000000e+00 -0.00000000e+00 1.55902417e-03
+ -0.00000000e+00 -0.00000000e+00 -0.00000000e+00 -0.00000000e+00 -0.00000000e+00 1.55902417e-03
+ Gd=
+ 2.03817642e-11
+ -1.80463098e-13 2.03568188e-11
+ -0.00000000e+00 -3.06011573e-13 2.03562492e-11
+ -0.00000000e+00 -0.00000000e+00 -1.84671880e-13 2.03582988e-11
+ -0.00000000e+00 -0.00000000e+00 -0.00000000e+00 -1.84177656e-13 2.03589413e-11
+ -0.00000000e+00 -0.00000000e+00 -0.00000000e+00 -0.00000000e+00 -1.79904341e-13 2.03818297e-11

.Model Wmodel_Trace598_Auto_435::MIPI_DSI1_CLK_N W MODELTYPE=RLGC N=4
+ Lo=
+ 3.30647936e-07
+ 4.17377146e-08 3.28848843e-07
+ 1.29425005e-08 4.84000301e-08 3.28848843e-07
+ 5.52654106e-09 1.29425005e-08 4.17377146e-08 3.30647936e-07
+ Co=
+ 1.03814504e-10
+ -4.46670159e-12 1.04315738e-10
+ -5.58396158e-13 -5.66916550e-12 1.04315738e-10
+ -2.44056777e-13 -5.58396158e-13 -4.46670159e-12 1.03814504e-10
+ Ro=
+ 3.96831067e+00
+ 0.00000000e+00 3.96831067e+00
+ 0.00000000e+00 0.00000000e+00 3.96831067e+00
+ 0.00000000e+00 0.00000000e+00 0.00000000e+00 3.96831067e+00
+ Go=
+ 0.00000000e+00
+ -0.00000000e+00 0.00000000e+00
+ -0.00000000e+00 -0.00000000e+00 0.00000000e+00
+ -0.00000000e+00 -0.00000000e+00 -0.00000000e+00 0.00000000e+00
+ Rs=
+ 1.55902417e-03
+ -0.00000000e+00 1.55902417e-03
+ -0.00000000e+00 -0.00000000e+00 1.55902417e-03
+ -0.00000000e+00 -0.00000000e+00 -0.00000000e+00 1.55902417e-03
+ Gd=
+ 2.03818222e-11
+ -1.80422025e-13 2.03569600e-11
+ -0.00000000e+00 -3.15398897e-13 2.03569600e-11
+ -0.00000000e+00 -0.00000000e+00 -1.80422025e-13 2.03818222e-11

.Model Wmodel_Trace607::MIPI_DSI1_CLK_N W MODELTYPE=RLGC N=1
+ Lo=
+ 3.32029740e-07
+ Co=
+ 1.03489020e-10
+ Ro=
+ 3.96831067e+00
+ Go=
+ 0.00000000e+00
+ Rs=
+ 1.55902417e-03
+ Gd=
+ 2.04067990e-11

.Model Wmodel_Trace610::MIPI_DSI1_CLK_N W MODELTYPE=RLGC N=1
+ Lo=
+ 3.32029740e-07
+ Co=
+ 1.03489020e-10
+ Ro=
+ 3.96831067e+00
+ Go=
+ 0.00000000e+00
+ Rs=
+ 1.55902417e-03
+ Gd=
+ 2.04067990e-11

.Model Wmodel_Trace610_Auto_406::MIPI_DSI1_CLK_N W MODELTYPE=RLGC N=1
+ Lo=
+ 3.32029740e-07
+ Co=
+ 1.03489020e-10
+ Ro=
+ 3.96831067e+00
+ Go=
+ 0.00000000e+00
+ Rs=
+ 1.55902417e-03
+ Gd=
+ 2.04067990e-11

.Model Wmodel_Trace611::MIPI_DSI1_CLK_N W MODELTYPE=RLGC N=1
+ Lo=
+ 3.32029740e-07
+ Co=
+ 1.03489020e-10
+ Ro=
+ 3.96831067e+00
+ Go=
+ 0.00000000e+00
+ Rs=
+ 1.55902417e-03
+ Gd=
+ 2.04067990e-11

.Model Wmodel_Trace627::MIPI_DSI1_CLK_N W MODELTYPE=RLGC N=1
+ Lo=
+ 3.32029740e-07
+ Co=
+ 1.03489020e-10
+ Ro=
+ 3.96831067e+00
+ Go=
+ 0.00000000e+00
+ Rs=
+ 1.55902417e-03
+ Gd=
+ 2.04067990e-11

.Model Wmodel_Trace627_Auto_467::MIPI_DSI1_CLK_N W MODELTYPE=RLGC N=1
+ Lo=
+ 3.32029740e-07
+ Co=
+ 1.03489020e-10
+ Ro=
+ 3.96831067e+00
+ Go=
+ 0.00000000e+00
+ Rs=
+ 1.55902417e-03
+ Gd=
+ 2.04067990e-11

.Model Wmodel_Trace627_Auto_487::MIPI_DSI1_CLK_N W MODELTYPE=RLGC N=1
+ Lo=
+ 3.32029740e-07
+ Co=
+ 1.03489020e-10
+ Ro=
+ 3.96831067e+00
+ Go=
+ 0.00000000e+00
+ Rs=
+ 1.55902417e-03
+ Gd=
+ 2.04067990e-11

.Model Wmodel_Trace628::MIPI_DSI1_CLK_N W MODELTYPE=RLGC N=1
+ Lo=
+ 3.32029740e-07
+ Co=
+ 1.03489020e-10
+ Ro=
+ 3.96831067e+00
+ Go=
+ 0.00000000e+00
+ Rs=
+ 1.55902417e-03
+ Gd=
+ 2.04067990e-11

.Model Wmodel_Trace628_Auto_720::MIPI_DSI1_CLK_N W MODELTYPE=RLGC N=1
+ Lo=
+ 3.32029740e-07
+ Co=
+ 1.03489020e-10
+ Ro=
+ 3.96831067e+00
+ Go=
+ 0.00000000e+00
+ Rs=
+ 1.55902417e-03
+ Gd=
+ 2.04067990e-11

.Model Wmodel_Trace628_Auto_725::MIPI_DSI1_CLK_N W MODELTYPE=RLGC N=1
+ Lo=
+ 3.32029740e-07
+ Co=
+ 1.03489020e-10
+ Ro=
+ 3.96831067e+00
+ Go=
+ 0.00000000e+00
+ Rs=
+ 1.55902417e-03
+ Gd=
+ 2.04067990e-11

.Model Wmodel_Trace630::MIPI_DSI1_CLK_N W MODELTYPE=RLGC N=1
+ Lo=
+ 3.32029740e-07
+ Co=
+ 1.03489020e-10
+ Ro=
+ 3.96831067e+00
+ Go=
+ 0.00000000e+00
+ Rs=
+ 1.55902417e-03
+ Gd=
+ 2.04067990e-11

.Model Wmodel_Trace632_Auto_741::MIPI_DSI1_CLK_N W MODELTYPE=RLGC N=1
+ Lo=
+ 3.32029740e-07
+ Co=
+ 1.03489020e-10
+ Ro=
+ 3.96831067e+00
+ Go=
+ 0.00000000e+00
+ Rs=
+ 1.55902417e-03
+ Gd=
+ 2.04067990e-11

.Model Wmodel_Trace634::MIPI_DSI1_CLK_N W MODELTYPE=RLGC N=1
+ Lo=
+ 3.32029740e-07
+ Co=
+ 1.03489020e-10
+ Ro=
+ 3.96831067e+00
+ Go=
+ 0.00000000e+00
+ Rs=
+ 1.55902417e-03
+ Gd=
+ 2.04067990e-11

.Model Wmodel_Trace636_Auto_1074::MIPI_DSI1_CLK_N W MODELTYPE=RLGC N=1
+ Lo=
+ 3.32029740e-07
+ Co=
+ 1.03489020e-10
+ Ro=
+ 3.96831067e+00
+ Go=
+ 0.00000000e+00
+ Rs=
+ 1.55902417e-03
+ Gd=
+ 2.04067990e-11

.Model Wmodel_Trace636_Auto_1082::MIPI_DSI1_CLK_N W MODELTYPE=RLGC N=1
+ Lo=
+ 3.32029740e-07
+ Co=
+ 1.03489020e-10
+ Ro=
+ 3.96831067e+00
+ Go=
+ 0.00000000e+00
+ Rs=
+ 1.55902417e-03
+ Gd=
+ 2.04067990e-11

.Model Wmodel_Trace636_Auto_1084::MIPI_DSI1_CLK_N W MODELTYPE=RLGC N=1
+ Lo=
+ 3.32029740e-07
+ Co=
+ 1.03489020e-10
+ Ro=
+ 3.96831067e+00
+ Go=
+ 0.00000000e+00
+ Rs=
+ 1.55902417e-03
+ Gd=
+ 2.04067990e-11

.Model Wmodel_Trace637::MIPI_DSI1_CLK_N W MODELTYPE=RLGC N=1
+ Lo=
+ 3.58484574e-07
+ Co=
+ 9.37055974e-11
+ Ro=
+ 4.84133902e+00
+ Go=
+ 0.00000000e+00
+ Rs=
+ 1.72420198e-03
+ Gd=
+ 1.82370500e-11

.Model Wmodel_Trace638::MIPI_DSI1_CLK_N W MODELTYPE=RLGC N=1
+ Lo=
+ 3.58484574e-07
+ Co=
+ 9.37055974e-11
+ Ro=
+ 4.84133902e+00
+ Go=
+ 0.00000000e+00
+ Rs=
+ 1.72420198e-03
+ Gd=
+ 1.82370500e-11

.Model Wmodel_Trace639::MIPI_DSI1_CLK_N W MODELTYPE=RLGC N=1
+ Lo=
+ 3.32029740e-07
+ Co=
+ 1.03489020e-10
+ Ro=
+ 3.96831067e+00
+ Go=
+ 0.00000000e+00
+ Rs=
+ 1.55902417e-03
+ Gd=
+ 2.04067990e-11

.Model Wmodel_Trace641::MIPI_DSI1_CLK_N W MODELTYPE=RLGC N=1
+ Lo=
+ 3.32029740e-07
+ Co=
+ 1.03489020e-10
+ Ro=
+ 3.96831067e+00
+ Go=
+ 0.00000000e+00
+ Rs=
+ 1.55902417e-03
+ Gd=
+ 2.04067990e-11

.Model Wmodel_Trace643::MIPI_DSI1_CLK_N W MODELTYPE=RLGC N=3
+ Lo=
+ 3.29435806e-07
+ 5.53574265e-08 3.28285515e-07
+ 1.40814117e-08 4.16882493e-08 3.30644033e-07
+ Co=
+ 1.04256808e-10
+ -7.01232440e-12 1.04560384e-10
+ -6.01955307e-13 -4.45918986e-12 1.03814436e-10
+ Ro=
+ 3.96831067e+00
+ 0.00000000e+00 3.96831067e+00
+ 0.00000000e+00 0.00000000e+00 3.96831067e+00
+ Go=
+ 0.00000000e+00
+ -0.00000000e+00 0.00000000e+00
+ -0.00000000e+00 -0.00000000e+00 0.00000000e+00
+ Rs=
+ 1.55902417e-03
+ -0.00000000e+00 1.55902417e-03
+ -0.00000000e+00 -0.00000000e+00 1.55902417e-03
+ Gd=
+ 2.03818724e-11
+ -4.65385346e-13 2.03602666e-11
+ -0.00000000e+00 -1.81154435e-13 2.03819078e-11

.Model Wmodel_Trace643_Auto_2042::MIPI_DSI1_CLK_N W MODELTYPE=RLGC N=1
+ Lo=
+ 3.32029740e-07
+ Co=
+ 1.03489020e-10
+ Ro=
+ 3.96831067e+00
+ Go=
+ 0.00000000e+00
+ Rs=
+ 1.55902417e-03
+ Gd=
+ 2.04067990e-11

.Model Wmodel_Trace644::MIPI_DSI1_CLK_N W MODELTYPE=RLGC N=1
+ Lo=
+ 3.32029740e-07
+ Co=
+ 1.03489020e-10
+ Ro=
+ 3.96831067e+00
+ Go=
+ 0.00000000e+00
+ Rs=
+ 1.55902417e-03
+ Gd=
+ 2.04067990e-11

.Model Wmodel_Trace644_Auto_2079::MIPI_DSI1_CLK_N W MODELTYPE=RLGC N=4
+ Lo=
+ 3.30616258e-07
+ 4.22304661e-08 3.28954506e-07
+ 1.27825303e-08 4.68358022e-08 3.28986290e-07
+ 5.48401110e-09 1.26944472e-08 4.17712754e-08 3.30651057e-07
+ Co=
+ 1.03825534e-10
+ -4.54975291e-12 1.04277647e-10
+ -5.54156152e-13 -5.37777889e-12 1.04266954e-10
+ -2.41998547e-13 -5.51222090e-13 -4.47146707e-12 1.03814590e-10
+ Ro=
+ 3.96831067e+00
+ 0.00000000e+00 3.96831067e+00
+ 0.00000000e+00 0.00000000e+00 3.96831067e+00
+ 0.00000000e+00 0.00000000e+00 0.00000000e+00 3.96831067e+00
+ Go=
+ 0.00000000e+00
+ -0.00000000e+00 0.00000000e+00
+ -0.00000000e+00 -0.00000000e+00 0.00000000e+00
+ -0.00000000e+00 -0.00000000e+00 -0.00000000e+00 0.00000000e+00
+ Rs=
+ 1.55902417e-03
+ -0.00000000e+00 1.55902417e-03
+ -0.00000000e+00 -0.00000000e+00 1.55902417e-03
+ -0.00000000e+00 -0.00000000e+00 -0.00000000e+00 1.55902417e-03
+ Gd=
+ 2.03815557e-11
+ -1.88343958e-13 2.03568442e-11
+ -0.00000000e+00 -2.82781115e-13 2.03570862e-11
+ -0.00000000e+00 -0.00000000e+00 -1.80415404e-13 2.03818312e-11

.Model Wmodel_Trace644_Auto_2087::MIPI_DSI1_CLK_N W MODELTYPE=RLGC N=3
+ Lo=
+ 3.30672455e-07
+ 4.18496508e-08 3.29346624e-07
+ 1.22470525e-08 4.37209281e-08 3.30534575e-07
+ Co=
+ 1.03813180e-10
+ -4.47988676e-12 1.04166098e-10
+ -5.51119421e-13 -4.80141312e-12 1.03858564e-10
+ Ro=
+ 3.96831067e+00
+ 0.00000000e+00 3.96831067e+00
+ 0.00000000e+00 0.00000000e+00 3.96831067e+00
+ Go=
+ 0.00000000e+00
+ -0.00000000e+00 0.00000000e+00
+ -0.00000000e+00 -0.00000000e+00 0.00000000e+00
+ Rs=
+ 1.55902417e-03
+ -0.00000000e+00 1.55902417e-03
+ -0.00000000e+00 -0.00000000e+00 1.55902417e-03
+ Gd=
+ 2.03820048e-11
+ -1.79671591e-13 2.03588181e-11
+ -0.00000000e+00 -2.12124382e-13 2.03810021e-11

.Model Wmodel_Trace644_Auto_2091::MIPI_DSI1_CLK_N W MODELTYPE=RLGC N=2
+ Lo=
+ 3.30748904e-07
+ 4.21593990e-08 3.30748904e-07
+ Co=
+ 1.03807716e-10
+ -4.52055469e-12 1.03807716e-10
+ Ro=
+ 3.96831067e+00
+ 0.00000000e+00 3.96831067e+00
+ Go=
+ 0.00000000e+00
+ -0.00000000e+00 0.00000000e+00
+ Rs=
+ 1.55902417e-03
+ -0.00000000e+00 1.55902417e-03
+ Gd=
+ 2.03827260e-11
+ -1.75097034e-13 2.03827260e-11

.Model Wmodel_Trace646::MIPI_DSI1_CLK_N W MODELTYPE=RLGC N=1
+ Lo=
+ 3.32029740e-07
+ Co=
+ 1.03489020e-10
+ Ro=
+ 3.96831067e+00
+ Go=
+ 0.00000000e+00
+ Rs=
+ 1.55902417e-03
+ Gd=
+ 2.04067990e-11

.Model Wmodel_Trace648::MIPI_DSI1_CLK_N W MODELTYPE=RLGC N=1
+ Lo=
+ 3.32029740e-07
+ Co=
+ 1.03489020e-10
+ Ro=
+ 3.96831067e+00
+ Go=
+ 0.00000000e+00
+ Rs=
+ 1.55902417e-03
+ Gd=
+ 2.04067990e-11

.Model Wmodel_Trace650::MIPI_DSI1_CLK_N W MODELTYPE=RLGC N=1
+ Lo=
+ 3.32029740e-07
+ Co=
+ 1.03489020e-10
+ Ro=
+ 3.96831067e+00
+ Go=
+ 0.00000000e+00
+ Rs=
+ 1.55902417e-03
+ Gd=
+ 2.04067990e-11

.Model Wmodel_Trace652::MIPI_DSI1_CLK_N W MODELTYPE=RLGC N=1
+ Lo=
+ 3.32029740e-07
+ Co=
+ 1.03489020e-10
+ Ro=
+ 3.96831067e+00
+ Go=
+ 0.00000000e+00
+ Rs=
+ 1.55902417e-03
+ Gd=
+ 2.04067990e-11

.Model Wmodel_Trace652_Auto_2067::MIPI_DSI1_CLK_N W MODELTYPE=RLGC N=2
+ Lo=
+ 3.30748904e-07
+ 4.21593990e-08 3.30748904e-07
+ Co=
+ 1.03807716e-10
+ -4.52055469e-12 1.03807716e-10
+ Ro=
+ 3.96831067e+00
+ 0.00000000e+00 3.96831067e+00
+ Go=
+ 0.00000000e+00
+ -0.00000000e+00 0.00000000e+00
+ Rs=
+ 1.55902417e-03
+ -0.00000000e+00 1.55902417e-03
+ Gd=
+ 2.03827260e-11
+ -1.75097034e-13 2.03827260e-11

.Model Wmodel_Trace652_Auto_2068::MIPI_DSI1_CLK_N W MODELTYPE=RLGC N=1
+ Lo=
+ 3.32029740e-07
+ Co=
+ 1.03489020e-10
+ Ro=
+ 3.96831067e+00
+ Go=
+ 0.00000000e+00
+ Rs=
+ 1.55902417e-03
+ Gd=
+ 2.04067990e-11

.Model Wmodel_Trace654::MIPI_DSI1_CLK_N W MODELTYPE=RLGC N=1
+ Lo=
+ 3.32029740e-07
+ Co=
+ 1.03489020e-10
+ Ro=
+ 3.96831067e+00
+ Go=
+ 0.00000000e+00
+ Rs=
+ 1.55902417e-03
+ Gd=
+ 2.04067990e-11

.Model Wmodel_Trace659::MIPI_DSI1_CLK_P W MODELTYPE=RLGC N=1
+ Lo=
+ 3.32029740e-07
+ Co=
+ 1.03489020e-10
+ Ro=
+ 3.96831067e+00
+ Go=
+ 0.00000000e+00
+ Rs=
+ 1.55902417e-03
+ Gd=
+ 2.04067990e-11

.Model Wmodel_Trace661#BP0::MIPI_DSI1_CLK_P W MODELTYPE=RLGC N=1
+ Lo=
+ 3.32029740e-07
+ Co=
+ 1.03489020e-10
+ Ro=
+ 3.96831067e+00
+ Go=
+ 0.00000000e+00
+ Rs=
+ 1.55902417e-03
+ Gd=
+ 2.04067990e-11

.Model Wmodel_Trace661#BP0_Auto_386::MIPI_DSI1_CLK_P W MODELTYPE=RLGC N=1
+ Lo=
+ 3.32029740e-07
+ Co=
+ 1.03489020e-10
+ Ro=
+ 3.96831067e+00
+ Go=
+ 0.00000000e+00
+ Rs=
+ 1.55902417e-03
+ Gd=
+ 2.04067990e-11

.Model Wmodel_Trace663::MIPI_DSI1_CLK_P W MODELTYPE=RLGC N=1
+ Lo=
+ 3.32029740e-07
+ Co=
+ 1.03489020e-10
+ Ro=
+ 3.96831067e+00
+ Go=
+ 0.00000000e+00
+ Rs=
+ 1.55902417e-03
+ Gd=
+ 2.04067990e-11

.Model Wmodel_Trace665::MIPI_DSI1_CLK_P W MODELTYPE=RLGC N=1
+ Lo=
+ 3.32029740e-07
+ Co=
+ 1.03489020e-10
+ Ro=
+ 3.96831067e+00
+ Go=
+ 0.00000000e+00
+ Rs=
+ 1.55902417e-03
+ Gd=
+ 2.04067990e-11

.Model Wmodel_Trace667::MIPI_DSI1_CLK_P W MODELTYPE=RLGC N=1
+ Lo=
+ 3.32029740e-07
+ Co=
+ 1.03489020e-10
+ Ro=
+ 3.96831067e+00
+ Go=
+ 0.00000000e+00
+ Rs=
+ 1.55902417e-03
+ Gd=
+ 2.04067990e-11

.Model Wmodel_Trace679::MIPI_DSI1_CLK_P W MODELTYPE=RLGC N=1
+ Lo=
+ 3.32029740e-07
+ Co=
+ 1.03489020e-10
+ Ro=
+ 3.96831067e+00
+ Go=
+ 0.00000000e+00
+ Rs=
+ 1.55902417e-03
+ Gd=
+ 2.04067990e-11

.Model Wmodel_Trace681_Auto_428::MIPI_DSI1_CLK_P W MODELTYPE=RLGC N=1
+ Lo=
+ 3.32029740e-07
+ Co=
+ 1.03489020e-10
+ Ro=
+ 3.96831067e+00
+ Go=
+ 0.00000000e+00
+ Rs=
+ 1.55902417e-03
+ Gd=
+ 2.04067990e-11

.Model Wmodel_Trace682::MIPI_DSI1_CLK_P W MODELTYPE=RLGC N=1
+ Lo=
+ 3.32029740e-07
+ Co=
+ 1.03489020e-10
+ Ro=
+ 3.96831067e+00
+ Go=
+ 0.00000000e+00
+ Rs=
+ 1.55902417e-03
+ Gd=
+ 2.04067990e-11

.Model Wmodel_Trace683_Auto_420::MIPI_DSI1_CLK_P W MODELTYPE=RLGC N=1
+ Lo=
+ 3.32029740e-07
+ Co=
+ 1.03489020e-10
+ Ro=
+ 3.96831067e+00
+ Go=
+ 0.00000000e+00
+ Rs=
+ 1.55902417e-03
+ Gd=
+ 2.04067990e-11

.Model Wmodel_Trace683_Auto_426::MIPI_DSI1_CLK_P W MODELTYPE=RLGC N=1
+ Lo=
+ 3.32029740e-07
+ Co=
+ 1.03489020e-10
+ Ro=
+ 3.96831067e+00
+ Go=
+ 0.00000000e+00
+ Rs=
+ 1.55902417e-03
+ Gd=
+ 2.04067990e-11

.Model Wmodel_Trace685::MIPI_DSI1_CLK_P W MODELTYPE=RLGC N=1
+ Lo=
+ 3.32029740e-07
+ Co=
+ 1.03489020e-10
+ Ro=
+ 3.96831067e+00
+ Go=
+ 0.00000000e+00
+ Rs=
+ 1.55902417e-03
+ Gd=
+ 2.04067990e-11

.Model Wmodel_Trace694::MIPI_DSI1_CLK_P W MODELTYPE=RLGC N=1
+ Lo=
+ 3.32029740e-07
+ Co=
+ 1.03489020e-10
+ Ro=
+ 3.96831067e+00
+ Go=
+ 0.00000000e+00
+ Rs=
+ 1.55902417e-03
+ Gd=
+ 2.04067990e-11

.Model Wmodel_Trace694_Auto_414::MIPI_DSI1_CLK_P W MODELTYPE=RLGC N=1
+ Lo=
+ 3.32029740e-07
+ Co=
+ 1.03489020e-10
+ Ro=
+ 3.96831067e+00
+ Go=
+ 0.00000000e+00
+ Rs=
+ 1.55902417e-03
+ Gd=
+ 2.04067990e-11

.Model Wmodel_Trace694_Auto_416::MIPI_DSI1_CLK_P W MODELTYPE=RLGC N=1
+ Lo=
+ 3.32029740e-07
+ Co=
+ 1.03489020e-10
+ Ro=
+ 3.96831067e+00
+ Go=
+ 0.00000000e+00
+ Rs=
+ 1.55902417e-03
+ Gd=
+ 2.04067990e-11

.Model Wmodel_Trace704::MIPI_DSI1_CLK_P W MODELTYPE=RLGC N=1
+ Lo=
+ 3.32029740e-07
+ Co=
+ 1.03489020e-10
+ Ro=
+ 3.96831067e+00
+ Go=
+ 0.00000000e+00
+ Rs=
+ 1.55902417e-03
+ Gd=
+ 2.04067990e-11

.Model Wmodel_Trace706::MIPI_DSI1_CLK_P W MODELTYPE=RLGC N=1
+ Lo=
+ 3.32029740e-07
+ Co=
+ 1.03489020e-10
+ Ro=
+ 3.96831067e+00
+ Go=
+ 0.00000000e+00
+ Rs=
+ 1.55902417e-03
+ Gd=
+ 2.04067990e-11

.Model Wmodel_Trace706_Auto_411::MIPI_DSI1_CLK_P W MODELTYPE=RLGC N=1
+ Lo=
+ 3.32029740e-07
+ Co=
+ 1.03489020e-10
+ Ro=
+ 3.96831067e+00
+ Go=
+ 0.00000000e+00
+ Rs=
+ 1.55902417e-03
+ Gd=
+ 2.04067990e-11

.Model Wmodel_Trace706_Auto_415::MIPI_DSI1_CLK_P W MODELTYPE=RLGC N=1
+ Lo=
+ 3.32029740e-07
+ Co=
+ 1.03489020e-10
+ Ro=
+ 3.96831067e+00
+ Go=
+ 0.00000000e+00
+ Rs=
+ 1.55902417e-03
+ Gd=
+ 2.04067990e-11

.Model Wmodel_Trace708::MIPI_DSI1_CLK_P W MODELTYPE=RLGC N=1
+ Lo=
+ 3.32029740e-07
+ Co=
+ 1.03489020e-10
+ Ro=
+ 3.96831067e+00
+ Go=
+ 0.00000000e+00
+ Rs=
+ 1.55902417e-03
+ Gd=
+ 2.04067990e-11

.Model Wmodel_Trace711::MIPI_DSI1_CLK_P W MODELTYPE=RLGC N=3
+ Lo=
+ 3.29953054e-07
+ 5.03493504e-08 3.28785870e-07
+ 1.33167390e-08 4.17639393e-08 3.30656359e-07
+ Co=
+ 1.04060147e-10
+ -6.01839676e-12 1.04365496e-10
+ -5.82097672e-13 -4.46883224e-12 1.03813972e-10
+ Ro=
+ 3.96831067e+00
+ 0.00000000e+00 3.96831067e+00
+ 0.00000000e+00 0.00000000e+00 3.96831067e+00
+ Go=
+ 0.00000000e+00
+ -0.00000000e+00 0.00000000e+00
+ -0.00000000e+00 -0.00000000e+00 0.00000000e+00
+ Rs=
+ 1.55902417e-03
+ -0.00000000e+00 1.55902417e-03
+ -0.00000000e+00 -0.00000000e+00 1.55902417e-03
+ Gd=
+ 2.03796478e-11
+ -3.46731846e-13 2.03577948e-11
+ -0.00000000e+00 -1.80576016e-13 2.03819432e-11

.Model Wmodel_Trace712::MIPI_DSI1_CLK_P W MODELTYPE=RLGC N=3
+ Lo=
+ 3.29955120e-07
+ 5.03279148e-08 3.28787866e-07
+ 1.33133924e-08 4.17642499e-08 3.30656411e-07
+ Co=
+ 1.04059392e-10
+ -6.01427763e-12 1.04364749e-10
+ -5.82006606e-13 -4.46887238e-12 1.03813970e-10
+ Ro=
+ 3.96831067e+00
+ 0.00000000e+00 3.96831067e+00
+ 0.00000000e+00 0.00000000e+00 3.96831067e+00
+ Go=
+ 0.00000000e+00
+ -0.00000000e+00 0.00000000e+00
+ -0.00000000e+00 -0.00000000e+00 0.00000000e+00
+ Rs=
+ 1.55902417e-03
+ -0.00000000e+00 1.55902417e-03
+ -0.00000000e+00 -0.00000000e+00 1.55902417e-03
+ Gd=
+ 2.03796451e-11
+ -3.46254405e-13 2.03577910e-11
+ -0.00000000e+00 -1.80573459e-13 2.03819434e-11

.Model Wmodel_Trace715::MIPI_DSI1_CLK_P W MODELTYPE=RLGC N=1
+ Lo=
+ 3.32029740e-07
+ Co=
+ 1.03489020e-10
+ Ro=
+ 3.96831067e+00
+ Go=
+ 0.00000000e+00
+ Rs=
+ 1.55902417e-03
+ Gd=
+ 2.04067990e-11

.Model Wmodel_Trace716::MIPI_DSI1_CLK_P W MODELTYPE=RLGC N=1
+ Lo=
+ 3.32029740e-07
+ Co=
+ 1.03489020e-10
+ Ro=
+ 3.96831067e+00
+ Go=
+ 0.00000000e+00
+ Rs=
+ 1.55902417e-03
+ Gd=
+ 2.04067990e-11

.Model Wmodel_Trace716_Auto_403::MIPI_DSI1_CLK_P W MODELTYPE=RLGC N=1
+ Lo=
+ 3.32029740e-07
+ Co=
+ 1.03489020e-10
+ Ro=
+ 3.96831067e+00
+ Go=
+ 0.00000000e+00
+ Rs=
+ 1.55902417e-03
+ Gd=
+ 2.04067990e-11

.Model Wmodel_Trace722::MIPI_DSI1_CLK_P W MODELTYPE=RLGC N=1
+ Lo=
+ 3.32029740e-07
+ Co=
+ 1.03489020e-10
+ Ro=
+ 3.96831067e+00
+ Go=
+ 0.00000000e+00
+ Rs=
+ 1.55902417e-03
+ Gd=
+ 2.04067990e-11

.Model Wmodel_Trace727::MIPI_DSI1_CLK_P W MODELTYPE=RLGC N=1
+ Lo=
+ 3.32029740e-07
+ Co=
+ 1.03489020e-10
+ Ro=
+ 3.96831067e+00
+ Go=
+ 0.00000000e+00
+ Rs=
+ 1.55902417e-03
+ Gd=
+ 2.04067990e-11

.Model Wmodel_Trace730::MIPI_DSI1_CLK_P W MODELTYPE=RLGC N=1
+ Lo=
+ 3.32029740e-07
+ Co=
+ 1.03489020e-10
+ Ro=
+ 3.96831067e+00
+ Go=
+ 0.00000000e+00
+ Rs=
+ 1.55902417e-03
+ Gd=
+ 2.04067990e-11

.Model Wmodel_Trace730_Auto_401::MIPI_DSI1_CLK_P W MODELTYPE=RLGC N=6
+ Lo=
+ 3.30417960e-07
+ 4.48485237e-08 3.29111064e-07
+ 1.23844637e-08 4.19819328e-08 3.28778137e-07
+ 5.62321834e-09 1.27916594e-08 4.76029131e-08 3.28780877e-07
+ 3.04371176e-09 5.42411780e-09 1.27621001e-08 4.18460794e-08 3.28928444e-07
+ 1.97965903e-09 3.09118235e-09 5.73400163e-09 1.27444903e-08 4.71766225e-08 3.30219130e-07
+ Co=
+ 1.03891563e-10
+ -5.00528026e-12 1.04217041e-10
+ -5.38446258e-13 -4.52278497e-12 1.04312320e-10
+ -2.33585482e-13 -5.39397853e-13 -5.52850529e-12 1.04310025e-10
+ -1.29432597e-13 -2.23812455e-13 -5.37272871e-13 -4.50077341e-12 1.04281142e-10
+ -8.74219256e-14 -1.30812518e-13 -2.36014625e-13 -5.48879882e-13 -5.42694510e-12 1.03959064e-10
+ Ro=
+ 3.96831067e+00
+ 0.00000000e+00 3.96831067e+00
+ 0.00000000e+00 0.00000000e+00 3.96831067e+00
+ 0.00000000e+00 0.00000000e+00 0.00000000e+00 3.96831067e+00
+ 0.00000000e+00 0.00000000e+00 0.00000000e+00 0.00000000e+00 3.96831067e+00
+ 0.00000000e+00 0.00000000e+00 0.00000000e+00 0.00000000e+00 0.00000000e+00 3.96831067e+00
+ Go=
+ 0.00000000e+00
+ -0.00000000e+00 0.00000000e+00
+ -0.00000000e+00 -0.00000000e+00 0.00000000e+00
+ -0.00000000e+00 -0.00000000e+00 -0.00000000e+00 0.00000000e+00
+ -0.00000000e+00 -0.00000000e+00 -0.00000000e+00 -0.00000000e+00 0.00000000e+00
+ -0.00000000e+00 -0.00000000e+00 -0.00000000e+00 -0.00000000e+00 -0.00000000e+00 0.00000000e+00
+ Rs=
+ 1.55902417e-03
+ -0.00000000e+00 1.55902417e-03
+ -0.00000000e+00 -0.00000000e+00 1.55902417e-03
+ -0.00000000e+00 -0.00000000e+00 -0.00000000e+00 1.55902417e-03
+ -0.00000000e+00 -0.00000000e+00 -0.00000000e+00 -0.00000000e+00 1.55902417e-03
+ -0.00000000e+00 -0.00000000e+00 -0.00000000e+00 -0.00000000e+00 -0.00000000e+00 1.55902417e-03
+ Gd=
+ 2.03802658e-11
+ -2.34600465e-13 2.03572003e-11
+ -0.00000000e+00 -1.94627398e-13 2.03559136e-11
+ -0.00000000e+00 -0.00000000e+00 -3.00903715e-13 2.03559507e-11
+ -0.00000000e+00 -0.00000000e+00 -0.00000000e+00 -1.93054198e-13 2.03566797e-11
+ -0.00000000e+00 -0.00000000e+00 -0.00000000e+00 -0.00000000e+00 -2.80513517e-13 2.03795608e-11

.Model Wmodel_Trace730_Auto_407::MIPI_DSI1_CLK_P W MODELTYPE=RLGC N=1
+ Lo=
+ 3.32029740e-07
+ Co=
+ 1.03489020e-10
+ Ro=
+ 3.96831067e+00
+ Go=
+ 0.00000000e+00
+ Rs=
+ 1.55902417e-03
+ Gd=
+ 2.04067990e-11

.Model Wmodel_Trace733::MIPI_DSI1_CLK_P W MODELTYPE=RLGC N=1
+ Lo=
+ 3.32029740e-07
+ Co=
+ 1.03489020e-10
+ Ro=
+ 3.96831067e+00
+ Go=
+ 0.00000000e+00
+ Rs=
+ 1.55902417e-03
+ Gd=
+ 2.04067990e-11

.Model Wmodel_Trace735::MIPI_DSI1_CLK_P W MODELTYPE=RLGC N=1
+ Lo=
+ 3.32029740e-07
+ Co=
+ 1.03489020e-10
+ Ro=
+ 3.96831067e+00
+ Go=
+ 0.00000000e+00
+ Rs=
+ 1.55902417e-03
+ Gd=
+ 2.04067990e-11

.Model Wmodel_Trace735_Auto_463::MIPI_DSI1_CLK_P W MODELTYPE=RLGC N=1
+ Lo=
+ 3.32029740e-07
+ Co=
+ 1.03489020e-10
+ Ro=
+ 3.96831067e+00
+ Go=
+ 0.00000000e+00
+ Rs=
+ 1.55902417e-03
+ Gd=
+ 2.04067990e-11

.Model Wmodel_Trace735_Auto_464::MIPI_DSI1_CLK_P W MODELTYPE=RLGC N=1
+ Lo=
+ 3.32029740e-07
+ Co=
+ 1.03489020e-10
+ Ro=
+ 3.96831067e+00
+ Go=
+ 0.00000000e+00
+ Rs=
+ 1.55902417e-03
+ Gd=
+ 2.04067990e-11

.Model Wmodel_Trace736::MIPI_DSI1_CLK_P W MODELTYPE=RLGC N=1
+ Lo=
+ 3.32029740e-07
+ Co=
+ 1.03489020e-10
+ Ro=
+ 3.96831067e+00
+ Go=
+ 0.00000000e+00
+ Rs=
+ 1.55902417e-03
+ Gd=
+ 2.04067990e-11

.Model Wmodel_Trace736_Auto_695::MIPI_DSI1_CLK_P W MODELTYPE=RLGC N=2
+ Lo=
+ 3.30748904e-07
+ 4.21593990e-08 3.30748904e-07
+ Co=
+ 1.03807716e-10
+ -4.52055469e-12 1.03807716e-10
+ Ro=
+ 3.96831067e+00
+ 0.00000000e+00 3.96831067e+00
+ Go=
+ 0.00000000e+00
+ -0.00000000e+00 0.00000000e+00
+ Rs=
+ 1.55902417e-03
+ -0.00000000e+00 1.55902417e-03
+ Gd=
+ 2.03827260e-11
+ -1.75097034e-13 2.03827260e-11

.Model Wmodel_Trace736_Auto_698::MIPI_DSI1_CLK_P W MODELTYPE=RLGC N=2
+ Lo=
+ 3.30748904e-07
+ 4.21593990e-08 3.30748904e-07
+ Co=
+ 1.03807716e-10
+ -4.52055469e-12 1.03807716e-10
+ Ro=
+ 3.96831067e+00
+ 0.00000000e+00 3.96831067e+00
+ Go=
+ 0.00000000e+00
+ -0.00000000e+00 0.00000000e+00
+ Rs=
+ 1.55902417e-03
+ -0.00000000e+00 1.55902417e-03
+ Gd=
+ 2.03827260e-11
+ -1.75097034e-13 2.03827260e-11

.Model Wmodel_Trace736_Auto_717::MIPI_DSI1_CLK_P W MODELTYPE=RLGC N=2
+ Lo=
+ 3.30748904e-07
+ 4.21593990e-08 3.30748904e-07
+ Co=
+ 1.03807716e-10
+ -4.52055469e-12 1.03807716e-10
+ Ro=
+ 3.96831067e+00
+ 0.00000000e+00 3.96831067e+00
+ Go=
+ 0.00000000e+00
+ -0.00000000e+00 0.00000000e+00
+ Rs=
+ 1.55902417e-03
+ -0.00000000e+00 1.55902417e-03
+ Gd=
+ 2.03827260e-11
+ -1.75097034e-13 2.03827260e-11

.Model Wmodel_Trace736_Auto_723::MIPI_DSI1_CLK_P W MODELTYPE=RLGC N=1
+ Lo=
+ 3.32029740e-07
+ Co=
+ 1.03489020e-10
+ Ro=
+ 3.96831067e+00
+ Go=
+ 0.00000000e+00
+ Rs=
+ 1.55902417e-03
+ Gd=
+ 2.04067990e-11

.Model Wmodel_Trace738::MIPI_DSI1_CLK_P W MODELTYPE=RLGC N=1
+ Lo=
+ 3.32029740e-07
+ Co=
+ 1.03489020e-10
+ Ro=
+ 3.96831067e+00
+ Go=
+ 0.00000000e+00
+ Rs=
+ 1.55902417e-03
+ Gd=
+ 2.04067990e-11

.Model Wmodel_Trace740::MIPI_DSI1_CLK_P W MODELTYPE=RLGC N=2
+ Lo=
+ 3.30747387e-07
+ 4.21804618e-08 3.30747387e-07
+ Co=
+ 1.03808206e-10
+ -4.52412165e-12 1.03808206e-10
+ Ro=
+ 3.96831067e+00
+ 0.00000000e+00 3.96831067e+00
+ Go=
+ 0.00000000e+00
+ -0.00000000e+00 0.00000000e+00
+ Rs=
+ 1.55902417e-03
+ -0.00000000e+00 1.55902417e-03
+ Gd=
+ 2.03827134e-11
+ -1.75454921e-13 2.03827134e-11

.Model Wmodel_Trace740_Auto_738::MIPI_DSI1_CLK_P W MODELTYPE=RLGC N=2
+ Lo=
+ 3.30739358e-07
+ 4.22917086e-08 3.30739358e-07
+ Co=
+ 1.03810808e-10
+ -4.54298124e-12 1.03810808e-10
+ Ro=
+ 3.96831067e+00
+ 0.00000000e+00 3.96831067e+00
+ Go=
+ 0.00000000e+00
+ -0.00000000e+00 0.00000000e+00
+ Rs=
+ 1.55902417e-03
+ -0.00000000e+00 1.55902417e-03
+ Gd=
+ 2.03826475e-11
+ -1.77349869e-13 2.03826475e-11

.Model Wmodel_Trace742::MIPI_DSI1_CLK_P W MODELTYPE=RLGC N=1
+ Lo=
+ 3.32029740e-07
+ Co=
+ 1.03489020e-10
+ Ro=
+ 3.96831067e+00
+ Go=
+ 0.00000000e+00
+ Rs=
+ 1.55902417e-03
+ Gd=
+ 2.04067990e-11

.Model Wmodel_Trace744_Auto_1072::MIPI_DSI1_CLK_P W MODELTYPE=RLGC N=1
+ Lo=
+ 3.32029740e-07
+ Co=
+ 1.03489020e-10
+ Ro=
+ 3.96831067e+00
+ Go=
+ 0.00000000e+00
+ Rs=
+ 1.55902417e-03
+ Gd=
+ 2.04067990e-11

.Model Wmodel_Trace744_Auto_1080::MIPI_DSI1_CLK_P W MODELTYPE=RLGC N=2
+ Lo=
+ 3.30739043e-07
+ 4.22960763e-08 3.30739043e-07
+ Co=
+ 1.03810911e-10
+ -4.54372237e-12 1.03810911e-10
+ Ro=
+ 3.96831067e+00
+ 0.00000000e+00 3.96831067e+00
+ Go=
+ 0.00000000e+00
+ -0.00000000e+00 0.00000000e+00
+ Rs=
+ 1.55902417e-03
+ -0.00000000e+00 1.55902417e-03
+ Gd=
+ 2.03826449e-11
+ -1.77424428e-13 2.03826449e-11

.Model Wmodel_Trace745::MIPI_DSI1_CLK_P W MODELTYPE=RLGC N=1
+ Lo=
+ 3.58484574e-07
+ Co=
+ 9.37055974e-11
+ Ro=
+ 4.84133902e+00
+ Go=
+ 0.00000000e+00
+ Rs=
+ 1.72420198e-03
+ Gd=
+ 1.82370500e-11

.Model Wmodel_Trace748::MIPI_DSI1_CLK_P W MODELTYPE=RLGC N=2
+ Lo=
+ 3.31790226e-07
+ 2.05024437e-08 3.31790226e-07
+ Co=
+ 1.03528708e-10
+ -1.54416564e-12 1.03528708e-10
+ Ro=
+ 3.96831067e+00
+ 0.00000000e+00 3.96831067e+00
+ Go=
+ 0.00000000e+00
+ -0.00000000e+00 0.00000000e+00
+ Rs=
+ 1.55902417e-03
+ -0.00000000e+00 1.55902417e-03
+ Gd=
+ 2.04004222e-11
+ -0.00000000e+00 2.04004222e-11

.Model Wmodel_Trace748_Auto_1942::MIPI_DSI1_CLK_P W MODELTYPE=RLGC N=1
+ Lo=
+ 3.32029740e-07
+ Co=
+ 1.03489020e-10
+ Ro=
+ 3.96831067e+00
+ Go=
+ 0.00000000e+00
+ Rs=
+ 1.55902417e-03
+ Gd=
+ 2.04067990e-11

.Model Wmodel_Trace749::MIPI_DSI1_CLK_P W MODELTYPE=RLGC N=3
+ Lo=
+ 3.30721949e-07
+ 4.12605445e-08 3.29526193e-07
+ 1.18319395e-08 4.18854433e-08 3.30677748e-07
+ Co=
+ 1.03798808e-10
+ -4.37954403e-12 1.04107291e-10
+ -5.38084546e-13 -4.48484266e-12 1.03813025e-10
+ Ro=
+ 3.96831067e+00
+ 0.00000000e+00 3.96831067e+00
+ 0.00000000e+00 0.00000000e+00 3.96831067e+00
+ Go=
+ 0.00000000e+00
+ -0.00000000e+00 0.00000000e+00
+ -0.00000000e+00 -0.00000000e+00 0.00000000e+00
+ Rs=
+ 1.55902417e-03
+ -0.00000000e+00 1.55902417e-03
+ -0.00000000e+00 -0.00000000e+00 1.55902417e-03
+ Gd=
+ 2.03824097e-11
+ -1.69083885e-13 2.03600979e-11
+ -0.00000000e+00 -1.79437902e-13 2.03820273e-11

.Model Wmodel_Trace751_Auto_2049::MIPI_DSI1_CLK_P W MODELTYPE=RLGC N=1
+ Lo=
+ 3.32029740e-07
+ Co=
+ 1.03489020e-10
+ Ro=
+ 3.96831067e+00
+ Go=
+ 0.00000000e+00
+ Rs=
+ 1.55902417e-03
+ Gd=
+ 2.04067990e-11

.Model Wmodel_Trace751_Auto_2050::MIPI_DSI1_CLK_P W MODELTYPE=RLGC N=1
+ Lo=
+ 3.32029740e-07
+ Co=
+ 1.03489020e-10
+ Ro=
+ 3.96831067e+00
+ Go=
+ 0.00000000e+00
+ Rs=
+ 1.55902417e-03
+ Gd=
+ 2.04067990e-11

.Model Wmodel_Trace752::MIPI_DSI1_CLK_P W MODELTYPE=RLGC N=1
+ Lo=
+ 3.32029740e-07
+ Co=
+ 1.03489020e-10
+ Ro=
+ 3.96831067e+00
+ Go=
+ 0.00000000e+00
+ Rs=
+ 1.55902417e-03
+ Gd=
+ 2.04067990e-11

.Model Wmodel_Trace753::MIPI_DSI1_CLK_P W MODELTYPE=RLGC N=1
+ Lo=
+ 3.32029740e-07
+ Co=
+ 1.03489020e-10
+ Ro=
+ 3.96831067e+00
+ Go=
+ 0.00000000e+00
+ Rs=
+ 1.55902417e-03
+ Gd=
+ 2.04067990e-11

.Model Wmodel_Trace753_Auto_2035::MIPI_DSI1_CLK_P W MODELTYPE=RLGC N=2
+ Lo=
+ 3.30749474e-07
+ 4.21514791e-08 3.30749474e-07
+ Co=
+ 1.03807531e-10
+ -4.51921379e-12 1.03807531e-10
+ Ro=
+ 3.96831067e+00
+ 0.00000000e+00 3.96831067e+00
+ Go=
+ 0.00000000e+00
+ -0.00000000e+00 0.00000000e+00
+ Rs=
+ 1.55902417e-03
+ -0.00000000e+00 1.55902417e-03
+ Gd=
+ 2.03827308e-11
+ -1.74962538e-13 2.03827308e-11

.Model Wmodel_Trace755_Auto_2080::MIPI_DSI1_CLK_P W MODELTYPE=RLGC N=1
+ Lo=
+ 3.32029740e-07
+ Co=
+ 1.03489020e-10
+ Ro=
+ 3.96831067e+00
+ Go=
+ 0.00000000e+00
+ Rs=
+ 1.55902417e-03
+ Gd=
+ 2.04067990e-11

.Model Wmodel_Trace757::MIPI_DSI1_CLK_P W MODELTYPE=RLGC N=1
+ Lo=
+ 3.32029740e-07
+ Co=
+ 1.03489020e-10
+ Ro=
+ 3.96831067e+00
+ Go=
+ 0.00000000e+00
+ Rs=
+ 1.55902417e-03
+ Gd=
+ 2.04067990e-11

.Model Wmodel_Trace759::MIPI_DSI1_CLK_P W MODELTYPE=RLGC N=1
+ Lo=
+ 3.32029740e-07
+ Co=
+ 1.03489020e-10
+ Ro=
+ 3.96831067e+00
+ Go=
+ 0.00000000e+00
+ Rs=
+ 1.55902417e-03
+ Gd=
+ 2.04067990e-11

.Model Wmodel_Trace759_Auto_2059::MIPI_DSI1_CLK_P W MODELTYPE=RLGC N=3
+ Lo=
+ 3.30682578e-07
+ 4.18887174e-08 3.29636738e-07
+ 1.15518578e-08 3.96573167e-08 3.30836133e-07
+ Co=
+ 1.03812467e-10
+ -4.48471199e-12 1.04072473e-10
+ -5.28972262e-13 -4.11366783e-12 1.03763824e-10
+ Ro=
+ 3.96831067e+00
+ 0.00000000e+00 3.96831067e+00
+ 0.00000000e+00 0.00000000e+00 3.96831067e+00
+ Go=
+ 0.00000000e+00
+ -0.00000000e+00 0.00000000e+00
+ -0.00000000e+00 -0.00000000e+00 0.00000000e+00
+ Rs=
+ 1.55902417e-03
+ -0.00000000e+00 1.55902417e-03
+ -0.00000000e+00 -0.00000000e+00 1.55902417e-03
+ Gd=
+ 2.03820549e-11
+ -1.78953579e-13 2.03611329e-11
+ -0.00000000e+00 -1.43137904e-13 2.03835177e-11

.Model Wmodel_Trace759_Auto_2069::MIPI_DSI1_CLK_P W MODELTYPE=RLGC N=2
+ Lo=
+ 3.30741111e-07
+ 4.22674528e-08 3.30741111e-07
+ Co=
+ 1.03810240e-10
+ -4.53886629e-12 1.03810240e-10
+ Ro=
+ 3.96831067e+00
+ 0.00000000e+00 3.96831067e+00
+ Go=
+ 0.00000000e+00
+ -0.00000000e+00 0.00000000e+00
+ Rs=
+ 1.55902417e-03
+ -0.00000000e+00 1.55902417e-03
+ Gd=
+ 2.03826618e-11
+ -1.76936027e-13 2.03826618e-11

.Model Wmodel_Trace759_Auto_2070::MIPI_DSI1_CLK_P W MODELTYPE=RLGC N=1
+ Lo=
+ 3.32029740e-07
+ Co=
+ 1.03489020e-10
+ Ro=
+ 3.96831067e+00
+ Go=
+ 0.00000000e+00
+ Rs=
+ 1.55902417e-03
+ Gd=
+ 2.04067990e-11

.Model Wmodel_Trace761::MIPI_DSI1_CLK_P W MODELTYPE=RLGC N=1
+ Lo=
+ 3.32029740e-07
+ Co=
+ 1.03489020e-10
+ Ro=
+ 3.96831067e+00
+ Go=
+ 0.00000000e+00
+ Rs=
+ 1.55902417e-03
+ Gd=
+ 2.04067990e-11

.Model Wmodel_Trace767::MIPI_DSI1_CLK_P W MODELTYPE=RLGC N=1
+ Lo=
+ 3.32029740e-07
+ Co=
+ 1.03489020e-10
+ Ro=
+ 3.96831067e+00
+ Go=
+ 0.00000000e+00
+ Rs=
+ 1.55902417e-03
+ Gd=
+ 2.04067990e-11

.Model Wmodel_Trace769::MIPI_DSI1_CLK_P W MODELTYPE=RLGC N=2
+ Lo=
+ 3.30751819e-07
+ 4.21188650e-08 3.30751819e-07
+ Co=
+ 1.03806772e-10
+ -4.51369374e-12 1.03806772e-10
+ Ro=
+ 3.96831067e+00
+ 0.00000000e+00 3.96831067e+00
+ Go=
+ 0.00000000e+00
+ -0.00000000e+00 0.00000000e+00
+ Rs=
+ 1.55902417e-03
+ -0.00000000e+00 1.55902417e-03
+ Gd=
+ 2.03827503e-11
+ -1.74409105e-13 2.03827503e-11

.Model Wmodel_Trace769_Auto_2820::MIPI_DSI1_CLK_P W MODELTYPE=RLGC N=1
+ Lo=
+ 3.32029740e-07
+ Co=
+ 1.03489020e-10
+ Ro=
+ 3.96831067e+00
+ Go=
+ 0.00000000e+00
+ Rs=
+ 1.55902417e-03
+ Gd=
+ 2.04067990e-11

.Model Wmodel_Trace778::MIPI_DSI1_CLK_P W MODELTYPE=RLGC N=1
+ Lo=
+ 3.32029740e-07
+ Co=
+ 1.03489020e-10
+ Ro=
+ 3.96831067e+00
+ Go=
+ 0.00000000e+00
+ Rs=
+ 1.55902417e-03
+ Gd=
+ 2.04067990e-11

.Model Wmodel_Trace792::MIPI_DSI1_CLK_P W MODELTYPE=RLGC N=1
+ Lo=
+ 3.32029740e-07
+ Co=
+ 1.03489020e-10
+ Ro=
+ 3.96831067e+00
+ Go=
+ 0.00000000e+00
+ Rs=
+ 1.55902417e-03
+ Gd=
+ 2.04067990e-11
