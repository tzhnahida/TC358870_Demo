*Wmodel Definition*
*TraceModel Definition*

.Model Wmodel_Trace2060::MIPI_DSI0_DATA3_N W MODELTYPE=RLGC N=1
+ Lo=
+ 3.32029740e-07
+ Co=
+ 1.03489020e-10
+ Ro=
+ 3.96831067e+00
+ Go=
+ 0.00000000e+00
+ Rs=
+ 1.55902417e-03
+ Gd=
+ 2.04067990e-11

.Model Wmodel_Trace2060_Auto_12::MIPI_DSI0_DATA3_N W MODELTYPE=RLGC N=1
+ Lo=
+ 3.32029740e-07
+ Co=
+ 1.03489020e-10
+ Ro=
+ 3.96831067e+00
+ Go=
+ 0.00000000e+00
+ Rs=
+ 1.55902417e-03
+ Gd=
+ 2.04067990e-11

.Model Wmodel_Trace2060_Auto_2::MIPI_DSI0_DATA3_N W MODELTYPE=RLGC N=1
+ Lo=
+ 3.32029740e-07
+ Co=
+ 1.03489020e-10
+ Ro=
+ 3.96831067e+00
+ Go=
+ 0.00000000e+00
+ Rs=
+ 1.55902417e-03
+ Gd=
+ 2.04067990e-11

.Model Wmodel_Trace2060_Auto_4::MIPI_DSI0_DATA3_N W MODELTYPE=RLGC N=1
+ Lo=
+ 3.32029740e-07
+ Co=
+ 1.03489020e-10
+ Ro=
+ 3.96831067e+00
+ Go=
+ 0.00000000e+00
+ Rs=
+ 1.55902417e-03
+ Gd=
+ 2.04067990e-11

.Model Wmodel_Trace2060_Auto_6::MIPI_DSI0_DATA3_N W MODELTYPE=RLGC N=1
+ Lo=
+ 3.32029740e-07
+ Co=
+ 1.03489020e-10
+ Ro=
+ 3.96831067e+00
+ Go=
+ 0.00000000e+00
+ Rs=
+ 1.55902417e-03
+ Gd=
+ 2.04067990e-11

.Model Wmodel_Trace2060_Auto_8::MIPI_DSI0_DATA3_N W MODELTYPE=RLGC N=1
+ Lo=
+ 3.32029740e-07
+ Co=
+ 1.03489020e-10
+ Ro=
+ 3.96831067e+00
+ Go=
+ 0.00000000e+00
+ Rs=
+ 1.55902417e-03
+ Gd=
+ 2.04067990e-11

.Model Wmodel_Trace2061::MIPI_DSI0_DATA3_N W MODELTYPE=RLGC N=1
+ Lo=
+ 3.32029740e-07
+ Co=
+ 1.03489020e-10
+ Ro=
+ 3.96831067e+00
+ Go=
+ 0.00000000e+00
+ Rs=
+ 1.55902417e-03
+ Gd=
+ 2.04067990e-11

.Model Wmodel_Trace2061_Auto_260::MIPI_DSI0_DATA3_N W MODELTYPE=RLGC N=2
+ Lo=
+ 3.30748904e-07
+ 4.21593990e-08 3.30748904e-07
+ Co=
+ 1.03807716e-10
+ -4.52055469e-12 1.03807716e-10
+ Ro=
+ 3.96831067e+00
+ 0.00000000e+00 3.96831067e+00
+ Go=
+ 0.00000000e+00
+ -0.00000000e+00 0.00000000e+00
+ Rs=
+ 1.55902417e-03
+ -0.00000000e+00 1.55902417e-03
+ Gd=
+ 2.03827260e-11
+ -1.75097034e-13 2.03827260e-11

.Model Wmodel_Trace2062::MIPI_DSI0_DATA3_N W MODELTYPE=RLGC N=1
+ Lo=
+ 3.32029740e-07
+ Co=
+ 1.03489020e-10
+ Ro=
+ 3.96831067e+00
+ Go=
+ 0.00000000e+00
+ Rs=
+ 1.55902417e-03
+ Gd=
+ 2.04067990e-11

.Model Wmodel_Trace2063::MIPI_DSI0_DATA3_N W MODELTYPE=RLGC N=1
+ Lo=
+ 3.32029740e-07
+ Co=
+ 1.03489020e-10
+ Ro=
+ 3.96831067e+00
+ Go=
+ 0.00000000e+00
+ Rs=
+ 1.55902417e-03
+ Gd=
+ 2.04067990e-11

.Model Wmodel_Trace2064::MIPI_DSI0_DATA3_N W MODELTYPE=RLGC N=1
+ Lo=
+ 3.32029740e-07
+ Co=
+ 1.03489020e-10
+ Ro=
+ 3.96831067e+00
+ Go=
+ 0.00000000e+00
+ Rs=
+ 1.55902417e-03
+ Gd=
+ 2.04067990e-11

.Model Wmodel_Trace2065::MIPI_DSI0_DATA3_N W MODELTYPE=RLGC N=1
+ Lo=
+ 3.32029740e-07
+ Co=
+ 1.03489020e-10
+ Ro=
+ 3.96831067e+00
+ Go=
+ 0.00000000e+00
+ Rs=
+ 1.55902417e-03
+ Gd=
+ 2.04067990e-11

.Model Wmodel_Trace2065_Auto_146::MIPI_DSI0_DATA3_N W MODELTYPE=RLGC N=2
+ Lo=
+ 3.30883663e-07
+ 4.02249004e-08 3.30883663e-07
+ Co=
+ 1.03764889e-10
+ -4.19815073e-12 1.03764889e-10
+ Ro=
+ 3.96831067e+00
+ 0.00000000e+00 3.96831067e+00
+ Go=
+ 0.00000000e+00
+ -0.00000000e+00 0.00000000e+00
+ Rs=
+ 1.55902417e-03
+ -0.00000000e+00 1.55902417e-03
+ Gd=
+ 2.03839866e-11
+ -1.43446471e-13 2.03839866e-11

.Model Wmodel_Trace2065_Auto_147::MIPI_DSI0_DATA3_N W MODELTYPE=RLGC N=1
+ Lo=
+ 3.32029740e-07
+ Co=
+ 1.03489020e-10
+ Ro=
+ 3.96831067e+00
+ Go=
+ 0.00000000e+00
+ Rs=
+ 1.55902417e-03
+ Gd=
+ 2.04067990e-11

.Model Wmodel_Trace2065_Auto_148::MIPI_DSI0_DATA3_N W MODELTYPE=RLGC N=2
+ Lo=
+ 3.30750325e-07
+ 4.21396463e-08 3.30750325e-07
+ Co=
+ 1.03807256e-10
+ -4.51721071e-12 1.03807256e-10
+ Ro=
+ 3.96831067e+00
+ 0.00000000e+00 3.96831067e+00
+ Go=
+ 0.00000000e+00
+ -0.00000000e+00 0.00000000e+00
+ Rs=
+ 1.55902417e-03
+ -0.00000000e+00 1.55902417e-03
+ Gd=
+ 2.03827378e-11
+ -1.74761667e-13 2.03827378e-11

.Model Wmodel_Trace2067::MIPI_DSI0_DATA3_N W MODELTYPE=RLGC N=1
+ Lo=
+ 3.32029740e-07
+ Co=
+ 1.03489020e-10
+ Ro=
+ 3.96831067e+00
+ Go=
+ 0.00000000e+00
+ Rs=
+ 1.55902417e-03
+ Gd=
+ 2.04067990e-11

.Model Wmodel_Trace2076::MIPI_DSI0_DATA2_N W MODELTYPE=RLGC N=1
+ Lo=
+ 3.32029740e-07
+ Co=
+ 1.03489020e-10
+ Ro=
+ 3.96831067e+00
+ Go=
+ 0.00000000e+00
+ Rs=
+ 1.55902417e-03
+ Gd=
+ 2.04067990e-11

.Model Wmodel_Trace2077#BP0::MIPI_DSI0_DATA2_N W MODELTYPE=RLGC N=1
+ Lo=
+ 3.32029740e-07
+ Co=
+ 1.03489020e-10
+ Ro=
+ 3.96831067e+00
+ Go=
+ 0.00000000e+00
+ Rs=
+ 1.55902417e-03
+ Gd=
+ 2.04067990e-11

.Model Wmodel_Trace2077#BP0_Auto_194::MIPI_DSI0_DATA2_N W MODELTYPE=RLGC N=2
+ Lo=
+ 3.30748904e-07
+ 4.21593990e-08 3.30748904e-07
+ Co=
+ 1.03807716e-10
+ -4.52055469e-12 1.03807716e-10
+ Ro=
+ 3.96831067e+00
+ 0.00000000e+00 3.96831067e+00
+ Go=
+ 0.00000000e+00
+ -0.00000000e+00 0.00000000e+00
+ Rs=
+ 1.55902417e-03
+ -0.00000000e+00 1.55902417e-03
+ Gd=
+ 2.03827260e-11
+ -1.75097034e-13 2.03827260e-11

.Model Wmodel_Trace2077#BP0_Auto_195::MIPI_DSI0_DATA2_N W MODELTYPE=RLGC N=1
+ Lo=
+ 3.32029740e-07
+ Co=
+ 1.03489020e-10
+ Ro=
+ 3.96831067e+00
+ Go=
+ 0.00000000e+00
+ Rs=
+ 1.55902417e-03
+ Gd=
+ 2.04067990e-11

.Model Wmodel_Trace2081::MIPI_DSI0_DATA2_N W MODELTYPE=RLGC N=1
+ Lo=
+ 3.32029740e-07
+ Co=
+ 1.03489020e-10
+ Ro=
+ 3.96831067e+00
+ Go=
+ 0.00000000e+00
+ Rs=
+ 1.55902417e-03
+ Gd=
+ 2.04067990e-11

.Model Wmodel_Trace2083_Auto_196::MIPI_DSI0_DATA2_N W MODELTYPE=RLGC N=2
+ Lo=
+ 3.31078363e-07
+ 3.71728283e-08 3.31078363e-07
+ Co=
+ 1.03705959e-10
+ -3.71079724e-12 1.03705959e-10
+ Ro=
+ 3.96831067e+00
+ 0.00000000e+00 3.96831067e+00
+ Go=
+ 0.00000000e+00
+ -0.00000000e+00 0.00000000e+00
+ Rs=
+ 1.55902417e-03
+ -0.00000000e+00 1.55902417e-03
+ Gd=
+ 2.03863230e-11
+ -9.85049115e-14 2.03863230e-11

.Model Wmodel_Trace2087::MIPI_DSI0_DATA2_N W MODELTYPE=RLGC N=1
+ Lo=
+ 3.32029740e-07
+ Co=
+ 1.03489020e-10
+ Ro=
+ 3.96831067e+00
+ Go=
+ 0.00000000e+00
+ Rs=
+ 1.55902417e-03
+ Gd=
+ 2.04067990e-11

.Model Wmodel_Trace2093::MIPI_DSI0_DATA2_N W MODELTYPE=RLGC N=1
+ Lo=
+ 3.32029740e-07
+ Co=
+ 1.03489020e-10
+ Ro=
+ 3.96831067e+00
+ Go=
+ 0.00000000e+00
+ Rs=
+ 1.55902417e-03
+ Gd=
+ 2.04067990e-11

.Model Wmodel_Trace2095::MIPI_DSI0_DATA2_N W MODELTYPE=RLGC N=2
+ Lo=
+ 3.30748904e-07
+ 4.21593990e-08 3.30748904e-07
+ Co=
+ 1.03807716e-10
+ -4.52055469e-12 1.03807716e-10
+ Ro=
+ 3.96831067e+00
+ 0.00000000e+00 3.96831067e+00
+ Go=
+ 0.00000000e+00
+ -0.00000000e+00 0.00000000e+00
+ Rs=
+ 1.55902417e-03
+ -0.00000000e+00 1.55902417e-03
+ Gd=
+ 2.03827260e-11
+ -1.75097034e-13 2.03827260e-11

.Model Wmodel_Trace2099::MIPI_DSI0_DATA2_N W MODELTYPE=RLGC N=1
+ Lo=
+ 3.32029740e-07
+ Co=
+ 1.03489020e-10
+ Ro=
+ 3.96831067e+00
+ Go=
+ 0.00000000e+00
+ Rs=
+ 1.55902417e-03
+ Gd=
+ 2.04067990e-11

.Model Wmodel_Trace2101_Auto_104::MIPI_DSI0_DATA2_N W MODELTYPE=RLGC N=1
+ Lo=
+ 3.32029740e-07
+ Co=
+ 1.03489020e-10
+ Ro=
+ 3.96831067e+00
+ Go=
+ 0.00000000e+00
+ Rs=
+ 1.55902417e-03
+ Gd=
+ 2.04067990e-11

.Model Wmodel_Trace2101_Auto_106::MIPI_DSI0_DATA2_N W MODELTYPE=RLGC N=1
+ Lo=
+ 3.32029740e-07
+ Co=
+ 1.03489020e-10
+ Ro=
+ 3.96831067e+00
+ Go=
+ 0.00000000e+00
+ Rs=
+ 1.55902417e-03
+ Gd=
+ 2.04067990e-11

.Model Wmodel_Trace2103::MIPI_DSI0_DATA2_N W MODELTYPE=RLGC N=1
+ Lo=
+ 3.32029740e-07
+ Co=
+ 1.03489020e-10
+ Ro=
+ 3.96831067e+00
+ Go=
+ 0.00000000e+00
+ Rs=
+ 1.55902417e-03
+ Gd=
+ 2.04067990e-11

.Model Wmodel_Trace2110::MIPI_DSI0_DATA2_N W MODELTYPE=RLGC N=1
+ Lo=
+ 3.32029740e-07
+ Co=
+ 1.03489020e-10
+ Ro=
+ 3.96831067e+00
+ Go=
+ 0.00000000e+00
+ Rs=
+ 1.55902417e-03
+ Gd=
+ 2.04067990e-11

.Model Wmodel_Trace2112_Auto_109::MIPI_DSI0_DATA2_N W MODELTYPE=RLGC N=1
+ Lo=
+ 3.32029740e-07
+ Co=
+ 1.03489020e-10
+ Ro=
+ 3.96831067e+00
+ Go=
+ 0.00000000e+00
+ Rs=
+ 1.55902417e-03
+ Gd=
+ 2.04067990e-11

.Model Wmodel_Trace2112_Auto_118::MIPI_DSI0_DATA2_N W MODELTYPE=RLGC N=1
+ Lo=
+ 3.32029740e-07
+ Co=
+ 1.03489020e-10
+ Ro=
+ 3.96831067e+00
+ Go=
+ 0.00000000e+00
+ Rs=
+ 1.55902417e-03
+ Gd=
+ 2.04067990e-11

.Model Wmodel_Trace2114::MIPI_DSI0_DATA2_N W MODELTYPE=RLGC N=1
+ Lo=
+ 3.32029740e-07
+ Co=
+ 1.03489020e-10
+ Ro=
+ 3.96831067e+00
+ Go=
+ 0.00000000e+00
+ Rs=
+ 1.55902417e-03
+ Gd=
+ 2.04067990e-11

.Model Wmodel_Trace2116::MIPI_DSI0_DATA2_N W MODELTYPE=RLGC N=1
+ Lo=
+ 3.32029740e-07
+ Co=
+ 1.03489020e-10
+ Ro=
+ 3.96831067e+00
+ Go=
+ 0.00000000e+00
+ Rs=
+ 1.55902417e-03
+ Gd=
+ 2.04067990e-11

.Model Wmodel_Trace2116_Auto_380::MIPI_DSI0_DATA2_N W MODELTYPE=RLGC N=2
+ Lo=
+ 3.30706087e-07
+ 4.27483681e-08 3.30706087e-07
+ Co=
+ 1.03821648e-10
+ -4.62075154e-12 1.03821648e-10
+ Ro=
+ 3.96831067e+00
+ 0.00000000e+00 3.96831067e+00
+ Go=
+ 0.00000000e+00
+ -0.00000000e+00 0.00000000e+00
+ Rs=
+ 1.55902417e-03
+ -0.00000000e+00 1.55902417e-03
+ Gd=
+ 2.03823845e-11
+ -1.85211227e-13 2.03823845e-11

.Model Wmodel_Trace2119::MIPI_DSI0_DATA2_N W MODELTYPE=RLGC N=1
+ Lo=
+ 3.32029740e-07
+ Co=
+ 1.03489020e-10
+ Ro=
+ 3.96831067e+00
+ Go=
+ 0.00000000e+00
+ Rs=
+ 1.55902417e-03
+ Gd=
+ 2.04067990e-11

.Model Wmodel_Trace2120::MIPI_DSI0_DATA2_N W MODELTYPE=RLGC N=2
+ Lo=
+ 3.30748904e-07
+ 4.21593990e-08 3.30748904e-07
+ Co=
+ 1.03807716e-10
+ -4.52055469e-12 1.03807716e-10
+ Ro=
+ 3.96831067e+00
+ 0.00000000e+00 3.96831067e+00
+ Go=
+ 0.00000000e+00
+ -0.00000000e+00 0.00000000e+00
+ Rs=
+ 1.55902417e-03
+ -0.00000000e+00 1.55902417e-03
+ Gd=
+ 2.03827260e-11
+ -1.75097034e-13 2.03827260e-11

.Model Wmodel_Trace2120_Auto_510::MIPI_DSI0_DATA2_N W MODELTYPE=RLGC N=1
+ Lo=
+ 3.32029740e-07
+ Co=
+ 1.03489020e-10
+ Ro=
+ 3.96831067e+00
+ Go=
+ 0.00000000e+00
+ Rs=
+ 1.55902417e-03
+ Gd=
+ 2.04067990e-11

.Model Wmodel_Trace2123::MIPI_DSI0_DATA2_N W MODELTYPE=RLGC N=1
+ Lo=
+ 3.58484574e-07
+ Co=
+ 9.37055974e-11
+ Ro=
+ 4.84133902e+00
+ Go=
+ 0.00000000e+00
+ Rs=
+ 1.72420198e-03
+ Gd=
+ 1.82370500e-11

.Model Wmodel_Trace2124::MIPI_DSI0_DATA2_N W MODELTYPE=RLGC N=1
+ Lo=
+ 3.58484574e-07
+ Co=
+ 9.37055974e-11
+ Ro=
+ 4.84133902e+00
+ Go=
+ 0.00000000e+00
+ Rs=
+ 1.72420198e-03
+ Gd=
+ 1.82370500e-11

.Model Wmodel_Trace2124_Auto_246::MIPI_DSI0_DATA2_N W MODELTYPE=RLGC N=4
+ Lo=
+ 3.57907612e-07
+ 3.21840801e-08 3.57063380e-07
+ 9.10436016e-09 3.45815696e-08 3.29240243e-07
+ 4.76004792e-09 1.20363085e-08 5.20507279e-08 3.29826566e-07
+ Co=
+ 9.38105418e-11
+ -2.42633512e-12 9.39580503e-11
+ -4.03423013e-13 -2.99715646e-12 1.04265452e-10
+ -1.96536511e-13 -4.87571039e-13 -6.33704450e-12 1.04116614e-10
+ Ro=
+ 4.84133902e+00
+ 0.00000000e+00 4.84133902e+00
+ 0.00000000e+00 0.00000000e+00 3.96831067e+00
+ 0.00000000e+00 0.00000000e+00 0.00000000e+00 3.96831067e+00
+ Go=
+ 0.00000000e+00
+ -0.00000000e+00 0.00000000e+00
+ -0.00000000e+00 -0.00000000e+00 0.00000000e+00
+ -0.00000000e+00 -0.00000000e+00 -0.00000000e+00 0.00000000e+00
+ Rs=
+ 1.72420198e-03
+ -0.00000000e+00 1.72420198e-03
+ -0.00000000e+00 -0.00000000e+00 1.55902417e-03
+ -0.00000000e+00 -0.00000000e+00 -0.00000000e+00 1.55902417e-03
+ Gd=
+ 1.82237639e-11
+ -1.85699629e-14 1.82079865e-11
+ -0.00000000e+00 -6.00813770e-14 2.03643109e-11
+ -0.00000000e+00 -0.00000000e+00 -3.81330922e-13 2.03800418e-11

.Model Wmodel_Trace2124_Auto_247::MIPI_DSI0_DATA2_N W MODELTYPE=RLGC N=1
+ Lo=
+ 3.58484574e-07
+ Co=
+ 9.37055974e-11
+ Ro=
+ 4.84133902e+00
+ Go=
+ 0.00000000e+00
+ Rs=
+ 1.72420198e-03
+ Gd=
+ 1.82370500e-11

.Model Wmodel_Trace2125::MIPI_DSI0_DATA2_N W MODELTYPE=RLGC N=1
+ Lo=
+ 3.58484574e-07
+ Co=
+ 9.37055974e-11
+ Ro=
+ 4.84133902e+00
+ Go=
+ 0.00000000e+00
+ Rs=
+ 1.72420198e-03
+ Gd=
+ 1.82370500e-11

.Model Wmodel_Trace2126::MIPI_DSI0_DATA2_N W MODELTYPE=RLGC N=1
+ Lo=
+ 3.58484574e-07
+ Co=
+ 9.37055974e-11
+ Ro=
+ 4.84133902e+00
+ Go=
+ 0.00000000e+00
+ Rs=
+ 1.72420198e-03
+ Gd=
+ 1.82370500e-11

.Model Wmodel_Trace2126_Auto_240::MIPI_DSI0_DATA2_N W MODELTYPE=RLGC N=4
+ Lo=
+ 3.57488322e-07
+ 4.09771572e-08 3.56330567e-07
+ 1.15506879e-08 4.06549874e-08 3.30375458e-07
+ 4.65817943e-09 1.00307130e-08 3.23376862e-08 3.31285697e-07
+ Co=
+ 9.39180251e-11
+ -3.51948264e-12 9.41514473e-11
+ -4.97245041e-13 -3.85549152e-12 1.03886362e-10
+ -1.99517122e-13 -4.26571539e-13 -2.99194634e-12 1.03639063e-10
+ Ro=
+ 4.84133902e+00
+ 0.00000000e+00 4.84133902e+00
+ 0.00000000e+00 0.00000000e+00 3.96831067e+00
+ 0.00000000e+00 0.00000000e+00 0.00000000e+00 3.96831067e+00
+ Go=
+ 0.00000000e+00
+ -0.00000000e+00 0.00000000e+00
+ -0.00000000e+00 -0.00000000e+00 0.00000000e+00
+ -0.00000000e+00 -0.00000000e+00 -0.00000000e+00 0.00000000e+00
+ Rs=
+ 1.72420198e-03
+ -0.00000000e+00 1.72420198e-03
+ -0.00000000e+00 -0.00000000e+00 1.55902417e-03
+ -0.00000000e+00 -0.00000000e+00 -0.00000000e+00 1.55902417e-03
+ Gd=
+ 1.82170669e-11
+ -1.06525876e-13 1.81975068e-11
+ -0.00000000e+00 -1.32306205e-13 2.03686234e-11
+ -0.00000000e+00 -0.00000000e+00 -4.60720278e-14 2.03897215e-11

.Model Wmodel_Trace2127::MIPI_DSI0_DATA2_N W MODELTYPE=RLGC N=1
+ Lo=
+ 3.32029740e-07
+ Co=
+ 1.03489020e-10
+ Ro=
+ 3.96831067e+00
+ Go=
+ 0.00000000e+00
+ Rs=
+ 1.55902417e-03
+ Gd=
+ 2.04067990e-11

.Model Wmodel_Trace2127_Auto_257::MIPI_DSI0_DATA2_N W MODELTYPE=RLGC N=4
+ Lo=
+ 3.30666416e-07
+ 4.18531435e-08 3.29461307e-07
+ 1.17148584e-08 4.09199162e-08 3.29461307e-07
+ 5.18282966e-09 1.17148584e-08 4.18531435e-08 3.30666416e-07
+ Co=
+ 1.03813853e-10
+ -4.48195268e-12 1.04110727e-10
+ -5.22117603e-13 -4.33324400e-12 1.04110727e-10
+ -2.30198028e-13 -5.22117603e-13 -4.48195268e-12 1.03813853e-10
+ Ro=
+ 3.96831067e+00
+ 0.00000000e+00 3.96831067e+00
+ 0.00000000e+00 0.00000000e+00 3.96831067e+00
+ 0.00000000e+00 0.00000000e+00 0.00000000e+00 3.96831067e+00
+ Go=
+ 0.00000000e+00
+ -0.00000000e+00 0.00000000e+00
+ -0.00000000e+00 -0.00000000e+00 0.00000000e+00
+ -0.00000000e+00 -0.00000000e+00 -0.00000000e+00 0.00000000e+00
+ Rs=
+ 1.55902417e-03
+ -0.00000000e+00 1.55902417e-03
+ -0.00000000e+00 -0.00000000e+00 1.55902417e-03
+ -0.00000000e+00 -0.00000000e+00 -0.00000000e+00 1.55902417e-03
+ Gd=
+ 2.03819020e-11
+ -1.79629987e-13 2.03595085e-11
+ -0.00000000e+00 -1.72171279e-13 2.03595085e-11
+ -0.00000000e+00 -0.00000000e+00 -1.79629987e-13 2.03819020e-11

.Model Wmodel_Trace2129::MIPI_DSI0_DATA2_N W MODELTYPE=RLGC N=1
+ Lo=
+ 3.32029740e-07
+ Co=
+ 1.03489020e-10
+ Ro=
+ 3.96831067e+00
+ Go=
+ 0.00000000e+00
+ Rs=
+ 1.55902417e-03
+ Gd=
+ 2.04067990e-11

.Model Wmodel_Trace2130::MIPI_DSI0_DATA2_N W MODELTYPE=RLGC N=2
+ Lo=
+ 3.31013857e-07
+ 3.82221558e-08 3.31013857e-07
+ Co=
+ 1.03725077e-10
+ -3.87536926e-12 1.03725077e-10
+ Ro=
+ 3.96831067e+00
+ 0.00000000e+00 3.96831067e+00
+ Go=
+ 0.00000000e+00
+ -0.00000000e+00 0.00000000e+00
+ Rs=
+ 1.55902417e-03
+ -0.00000000e+00 1.55902417e-03
+ Gd=
+ 2.03854798e-11
+ -1.13257428e-13 2.03854798e-11

.Model Wmodel_Trace2132::MIPI_DSI0_DATA2_N W MODELTYPE=RLGC N=2
+ Lo=
+ 3.30767262e-07
+ 4.19032646e-08 3.30767262e-07
+ Co=
+ 1.03801789e-10
+ -4.47727570e-12 1.03801789e-10
+ Ro=
+ 3.96831067e+00
+ 0.00000000e+00 3.96831067e+00
+ Go=
+ 0.00000000e+00
+ -0.00000000e+00 0.00000000e+00
+ Rs=
+ 1.55902417e-03
+ -0.00000000e+00 1.55902417e-03
+ Gd=
+ 2.03828811e-11
+ -1.70767690e-13 2.03828811e-11

.Model Wmodel_Trace2132_Auto_68::MIPI_DSI0_DATA2_N W MODELTYPE=RLGC N=1
+ Lo=
+ 3.32029740e-07
+ Co=
+ 1.03489020e-10
+ Ro=
+ 3.96831067e+00
+ Go=
+ 0.00000000e+00
+ Rs=
+ 1.55902417e-03
+ Gd=
+ 2.04067990e-11

.Model Wmodel_Trace2133::MIPI_DSI0_DATA2_N W MODELTYPE=RLGC N=1
+ Lo=
+ 3.32029740e-07
+ Co=
+ 1.03489020e-10
+ Ro=
+ 3.96831067e+00
+ Go=
+ 0.00000000e+00
+ Rs=
+ 1.55902417e-03
+ Gd=
+ 2.04067990e-11

.Model Wmodel_Trace2133_Auto_140::MIPI_DSI0_DATA2_N W MODELTYPE=RLGC N=2
+ Lo=
+ 3.30748904e-07
+ 4.21593990e-08 3.30748904e-07
+ Co=
+ 1.03807716e-10
+ -4.52055469e-12 1.03807716e-10
+ Ro=
+ 3.96831067e+00
+ 0.00000000e+00 3.96831067e+00
+ Go=
+ 0.00000000e+00
+ -0.00000000e+00 0.00000000e+00
+ Rs=
+ 1.55902417e-03
+ -0.00000000e+00 1.55902417e-03
+ Gd=
+ 2.03827260e-11
+ -1.75097034e-13 2.03827260e-11

.Model Wmodel_Trace2133_Auto_141::MIPI_DSI0_DATA2_N W MODELTYPE=RLGC N=1
+ Lo=
+ 3.32029740e-07
+ Co=
+ 1.03489020e-10
+ Ro=
+ 3.96831067e+00
+ Go=
+ 0.00000000e+00
+ Rs=
+ 1.55902417e-03
+ Gd=
+ 2.04067990e-11

.Model Wmodel_Trace2135::MIPI_DSI0_DATA2_N W MODELTYPE=RLGC N=1
+ Lo=
+ 3.32029740e-07
+ Co=
+ 1.03489020e-10
+ Ro=
+ 3.96831067e+00
+ Go=
+ 0.00000000e+00
+ Rs=
+ 1.55902417e-03
+ Gd=
+ 2.04067990e-11

.Model Wmodel_Trace2136::MIPI_DSI0_DATA2_N W MODELTYPE=RLGC N=2
+ Lo=
+ 3.30748548e-07
+ 4.21643423e-08 3.30748548e-07
+ Co=
+ 1.03807831e-10
+ -4.52139172e-12 1.03807831e-10
+ Ro=
+ 3.96831067e+00
+ 0.00000000e+00 3.96831067e+00
+ Go=
+ 0.00000000e+00
+ -0.00000000e+00 0.00000000e+00
+ Rs=
+ 1.55902417e-03
+ -0.00000000e+00 1.55902417e-03
+ Gd=
+ 2.03827231e-11
+ -1.75181003e-13 2.03827231e-11

.Model Wmodel_Trace2136_Auto_143::MIPI_DSI0_DATA2_N W MODELTYPE=RLGC N=1
+ Lo=
+ 3.32029740e-07
+ Co=
+ 1.03489020e-10
+ Ro=
+ 3.96831067e+00
+ Go=
+ 0.00000000e+00
+ Rs=
+ 1.55902417e-03
+ Gd=
+ 2.04067990e-11

.Model Wmodel_Trace2139::MIPI_DSI0_DATA2_N W MODELTYPE=RLGC N=1
+ Lo=
+ 3.32029740e-07
+ Co=
+ 1.03489020e-10
+ Ro=
+ 3.96831067e+00
+ Go=
+ 0.00000000e+00
+ Rs=
+ 1.55902417e-03
+ Gd=
+ 2.04067990e-11

.Model Wmodel_Trace2491::MIPI_DSI0_DATA3_P W MODELTYPE=RLGC N=2
+ Lo=
+ 3.31245235e-07
+ 3.42442652e-08 3.31245235e-07
+ Co=
+ 1.03658522e-10
+ -3.26839824e-12 1.03658522e-10
+ Ro=
+ 3.96831067e+00
+ 0.00000000e+00 3.96831067e+00
+ Go=
+ 0.00000000e+00
+ -0.00000000e+00 0.00000000e+00
+ Rs=
+ 1.55902417e-03
+ -0.00000000e+00 1.55902417e-03
+ Gd=
+ 2.03888319e-11
+ -6.12744516e-14 2.03888319e-11

.Model Wmodel_Trace2493::MIPI_DSI0_DATA3_P W MODELTYPE=RLGC N=1
+ Lo=
+ 3.32029740e-07
+ Co=
+ 1.03489020e-10
+ Ro=
+ 3.96831067e+00
+ Go=
+ 0.00000000e+00
+ Rs=
+ 1.55902417e-03
+ Gd=
+ 2.04067990e-11

.Model Wmodel_Trace2494::MIPI_DSI0_DATA3_P W MODELTYPE=RLGC N=2
+ Lo=
+ 3.29928812e-07
+ 5.18994163e-08 3.29928812e-07
+ Co=
+ 1.04098061e-10
+ -6.29510107e-12 1.04098061e-10
+ Ro=
+ 3.96831067e+00
+ 0.00000000e+00 3.96831067e+00
+ Go=
+ 0.00000000e+00
+ -0.00000000e+00 0.00000000e+00
+ Rs=
+ 1.55902417e-03
+ -0.00000000e+00 1.55902417e-03
+ Gd=
+ 2.03806934e-11
+ -3.69704998e-13 2.03806934e-11

.Model Wmodel_Trace2495::MIPI_DSI0_DATA3_P W MODELTYPE=RLGC N=1
+ Lo=
+ 3.32029740e-07
+ Co=
+ 1.03489020e-10
+ Ro=
+ 3.96831067e+00
+ Go=
+ 0.00000000e+00
+ Rs=
+ 1.55902417e-03
+ Gd=
+ 2.04067990e-11

.Model Wmodel_Trace2496::MIPI_DSI0_DATA3_P W MODELTYPE=RLGC N=2
+ Lo=
+ 3.30778366e-07
+ 4.17472544e-08 3.30778366e-07
+ Co=
+ 1.03798218e-10
+ -4.45100269e-12 1.03798218e-10
+ Ro=
+ 3.96831067e+00
+ 0.00000000e+00 3.96831067e+00
+ Go=
+ 0.00000000e+00
+ -0.00000000e+00 0.00000000e+00
+ Rs=
+ 1.55902417e-03
+ -0.00000000e+00 1.55902417e-03
+ Gd=
+ 2.03829774e-11
+ -1.68151335e-13 2.03829774e-11

.Model Wmodel_Trace2516::MIPI_DSI0_DATA3_P W MODELTYPE=RLGC N=1
+ Lo=
+ 3.32029740e-07
+ Co=
+ 1.03489020e-10
+ Ro=
+ 3.96831067e+00
+ Go=
+ 0.00000000e+00
+ Rs=
+ 1.55902417e-03
+ Gd=
+ 2.04067990e-11

.Model Wmodel_Trace2518::MIPI_DSI0_DATA3_P W MODELTYPE=RLGC N=2
+ Lo=
+ 3.30778715e-07
+ 4.17423300e-08 3.30778715e-07
+ Co=
+ 1.03798106e-10
+ -4.45017448e-12 1.03798106e-10
+ Ro=
+ 3.96831067e+00
+ 0.00000000e+00 3.96831067e+00
+ Go=
+ 0.00000000e+00
+ -0.00000000e+00 0.00000000e+00
+ Rs=
+ 1.55902417e-03
+ -0.00000000e+00 1.55902417e-03
+ Gd=
+ 2.03829805e-11
+ -1.68069005e-13 2.03829805e-11

.Model Wmodel_Trace2538::MIPI_DSI0_DATA3_P W MODELTYPE=RLGC N=1
+ Lo=
+ 3.32029740e-07
+ Co=
+ 1.03489020e-10
+ Ro=
+ 3.96831067e+00
+ Go=
+ 0.00000000e+00
+ Rs=
+ 1.55902417e-03
+ Gd=
+ 2.04067990e-11

.Model Wmodel_Trace2540::MIPI_DSI0_DATA3_P W MODELTYPE=RLGC N=2
+ Lo=
+ 3.30778715e-07
+ 4.17423300e-08 3.30778715e-07
+ Co=
+ 1.03798106e-10
+ -4.45017448e-12 1.03798106e-10
+ Ro=
+ 3.96831067e+00
+ 0.00000000e+00 3.96831067e+00
+ Go=
+ 0.00000000e+00
+ -0.00000000e+00 0.00000000e+00
+ Rs=
+ 1.55902417e-03
+ -0.00000000e+00 1.55902417e-03
+ Gd=
+ 2.03829805e-11
+ -1.68069005e-13 2.03829805e-11

.Model Wmodel_Trace2560::MIPI_DSI0_DATA3_P W MODELTYPE=RLGC N=1
+ Lo=
+ 3.32029740e-07
+ Co=
+ 1.03489020e-10
+ Ro=
+ 3.96831067e+00
+ Go=
+ 0.00000000e+00
+ Rs=
+ 1.55902417e-03
+ Gd=
+ 2.04067990e-11

.Model Wmodel_Trace2562::MIPI_DSI0_DATA3_P W MODELTYPE=RLGC N=2
+ Lo=
+ 3.30778715e-07
+ 4.17423300e-08 3.30778715e-07
+ Co=
+ 1.03798106e-10
+ -4.45017448e-12 1.03798106e-10
+ Ro=
+ 3.96831067e+00
+ 0.00000000e+00 3.96831067e+00
+ Go=
+ 0.00000000e+00
+ -0.00000000e+00 0.00000000e+00
+ Rs=
+ 1.55902417e-03
+ -0.00000000e+00 1.55902417e-03
+ Gd=
+ 2.03829805e-11
+ -1.68069005e-13 2.03829805e-11

.Model Wmodel_Trace2582::MIPI_DSI0_DATA3_P W MODELTYPE=RLGC N=1
+ Lo=
+ 3.32029740e-07
+ Co=
+ 1.03489020e-10
+ Ro=
+ 3.96831067e+00
+ Go=
+ 0.00000000e+00
+ Rs=
+ 1.55902417e-03
+ Gd=
+ 2.04067990e-11

.Model Wmodel_Trace2584::MIPI_DSI0_DATA3_P W MODELTYPE=RLGC N=2
+ Lo=
+ 3.30777724e-07
+ 4.17562902e-08 3.30777724e-07
+ Co=
+ 1.03798424e-10
+ -4.45252254e-12 1.03798424e-10
+ Ro=
+ 3.96831067e+00
+ 0.00000000e+00 3.96831067e+00
+ Go=
+ 0.00000000e+00
+ -0.00000000e+00 0.00000000e+00
+ Rs=
+ 1.55902417e-03
+ -0.00000000e+00 1.55902417e-03
+ Gd=
+ 2.03829718e-11
+ -1.68302442e-13 2.03829718e-11

.Model Wmodel_Trace2584_Auto_14::MIPI_DSI0_DATA3_P W MODELTYPE=RLGC N=1
+ Lo=
+ 3.32029740e-07
+ Co=
+ 1.03489020e-10
+ Ro=
+ 3.96831067e+00
+ Go=
+ 0.00000000e+00
+ Rs=
+ 1.55902417e-03
+ Gd=
+ 2.04067990e-11

.Model Wmodel_Trace2585_Auto_263::MIPI_DSI0_DATA3_P W MODELTYPE=RLGC N=1
+ Lo=
+ 3.32029740e-07
+ Co=
+ 1.03489020e-10
+ Ro=
+ 3.96831067e+00
+ Go=
+ 0.00000000e+00
+ Rs=
+ 1.55902417e-03
+ Gd=
+ 2.04067990e-11

.Model Wmodel_Trace2586::MIPI_DSI0_DATA3_P W MODELTYPE=RLGC N=1
+ Lo=
+ 3.32029740e-07
+ Co=
+ 1.03489020e-10
+ Ro=
+ 3.96831067e+00
+ Go=
+ 0.00000000e+00
+ Rs=
+ 1.55902417e-03
+ Gd=
+ 2.04067990e-11

.Model Wmodel_Trace2587::MIPI_DSI0_DATA3_P W MODELTYPE=RLGC N=1
+ Lo=
+ 3.32029740e-07
+ Co=
+ 1.03489020e-10
+ Ro=
+ 3.96831067e+00
+ Go=
+ 0.00000000e+00
+ Rs=
+ 1.55902417e-03
+ Gd=
+ 2.04067990e-11

.Model Wmodel_Trace2587_Auto_242::MIPI_DSI0_DATA3_P W MODELTYPE=RLGC N=1
+ Lo=
+ 3.32029740e-07
+ Co=
+ 1.03489020e-10
+ Ro=
+ 3.96831067e+00
+ Go=
+ 0.00000000e+00
+ Rs=
+ 1.55902417e-03
+ Gd=
+ 2.04067990e-11

.Model Wmodel_Trace2588::MIPI_DSI0_DATA3_P W MODELTYPE=RLGC N=1
+ Lo=
+ 3.32029740e-07
+ Co=
+ 1.03489020e-10
+ Ro=
+ 3.96831067e+00
+ Go=
+ 0.00000000e+00
+ Rs=
+ 1.55902417e-03
+ Gd=
+ 2.04067990e-11

.Model Wmodel_Trace2589_Auto_245::MIPI_DSI0_DATA3_P W MODELTYPE=RLGC N=1
+ Lo=
+ 3.32029740e-07
+ Co=
+ 1.03489020e-10
+ Ro=
+ 3.96831067e+00
+ Go=
+ 0.00000000e+00
+ Rs=
+ 1.55902417e-03
+ Gd=
+ 2.04067990e-11

.Model Wmodel_Trace2599::MIPI_DSI0_DATA2_P W MODELTYPE=RLGC N=1
+ Lo=
+ 3.32029740e-07
+ Co=
+ 1.03489020e-10
+ Ro=
+ 3.96831067e+00
+ Go=
+ 0.00000000e+00
+ Rs=
+ 1.55902417e-03
+ Gd=
+ 2.04067990e-11

.Model Wmodel_Trace2603::MIPI_DSI0_DATA2_P W MODELTYPE=RLGC N=1
+ Lo=
+ 3.32029740e-07
+ Co=
+ 1.03489020e-10
+ Ro=
+ 3.96831067e+00
+ Go=
+ 0.00000000e+00
+ Rs=
+ 1.55902417e-03
+ Gd=
+ 2.04067990e-11

.Model Wmodel_Trace2605::MIPI_DSI0_DATA2_P W MODELTYPE=RLGC N=1
+ Lo=
+ 3.32029740e-07
+ Co=
+ 1.03489020e-10
+ Ro=
+ 3.96831067e+00
+ Go=
+ 0.00000000e+00
+ Rs=
+ 1.55902417e-03
+ Gd=
+ 2.04067990e-11

.Model Wmodel_Trace2605_Auto_199::MIPI_DSI0_DATA2_P W MODELTYPE=RLGC N=3
+ Lo=
+ 3.30682500e-07
+ 4.19037676e-08 3.29657895e-07
+ 1.14953743e-08 3.93242171e-08 3.30859039e-07
+ Co=
+ 1.03812690e-10
+ -4.48712756e-12 1.04065952e-10
+ -5.27101429e-13 -4.05934022e-12 1.03756935e-10
+ Ro=
+ 3.96831067e+00
+ 0.00000000e+00 3.96831067e+00
+ 0.00000000e+00 0.00000000e+00 3.96831067e+00
+ Go=
+ 0.00000000e+00
+ -0.00000000e+00 0.00000000e+00
+ -0.00000000e+00 -0.00000000e+00 0.00000000e+00
+ Rs=
+ 1.55902417e-03
+ -0.00000000e+00 1.55902417e-03
+ -0.00000000e+00 -0.00000000e+00 1.55902417e-03
+ Gd=
+ 2.03820519e-11
+ -1.79099615e-13 2.03613556e-11
+ -0.00000000e+00 -1.37963647e-13 2.03837636e-11

.Model Wmodel_Trace2605_Auto_200::MIPI_DSI0_DATA2_P W MODELTYPE=RLGC N=1
+ Lo=
+ 3.32029740e-07
+ Co=
+ 1.03489020e-10
+ Ro=
+ 3.96831067e+00
+ Go=
+ 0.00000000e+00
+ Rs=
+ 1.55902417e-03
+ Gd=
+ 2.04067990e-11

.Model Wmodel_Trace2605_Auto_201::MIPI_DSI0_DATA2_P W MODELTYPE=RLGC N=2
+ Lo=
+ 3.30715407e-07
+ 4.26211454e-08 3.30715407e-07
+ Co=
+ 1.03818602e-10
+ -4.59902819e-12 1.03818602e-10
+ Ro=
+ 3.96831067e+00
+ 0.00000000e+00 3.96831067e+00
+ Go=
+ 0.00000000e+00
+ -0.00000000e+00 0.00000000e+00
+ Rs=
+ 1.55902417e-03
+ -0.00000000e+00 1.55902417e-03
+ Gd=
+ 2.03824564e-11
+ -1.83007748e-13 2.03824564e-11

.Model Wmodel_Trace2607::MIPI_DSI0_DATA2_P W MODELTYPE=RLGC N=1
+ Lo=
+ 3.32029740e-07
+ Co=
+ 1.03489020e-10
+ Ro=
+ 3.96831067e+00
+ Go=
+ 0.00000000e+00
+ Rs=
+ 1.55902417e-03
+ Gd=
+ 2.04067990e-11

.Model Wmodel_Trace2611::MIPI_DSI0_DATA2_P W MODELTYPE=RLGC N=6
+ Lo=
+ 3.30662015e-07
+ 4.18472084e-08 3.29461457e-07
+ 1.16547780e-08 4.06511017e-08 3.29357941e-07
+ 5.13016412e-09 1.16288980e-08 4.19942167e-08 3.29225288e-07
+ 2.86306629e-09 5.13179599e-09 1.19476027e-08 4.24831512e-08 3.29291759e-07
+ 1.83816497e-09 2.87216138e-09 5.24586453e-09 1.20462687e-08 4.22823051e-08 3.30622599e-07
+ Co=
+ 1.03814255e-10
+ -4.48161290e-12 1.04106846e-10
+ -5.19028017e-13 -4.29159246e-12 1.04122543e-10
+ -2.20591955e-13 -5.06461407e-13 -4.52135584e-12 1.04165349e-10
+ -1.23940425e-13 -2.15251330e-13 -5.16966794e-13 -4.60372300e-12 1.04160636e-10
+ -8.32544670e-14 -1.24882065e-13 -2.25332578e-13 -5.31245278e-13 -4.55678609e-12 1.03825437e-10
+ Ro=
+ 3.96831067e+00
+ 0.00000000e+00 3.96831067e+00
+ 0.00000000e+00 0.00000000e+00 3.96831067e+00
+ 0.00000000e+00 0.00000000e+00 0.00000000e+00 3.96831067e+00
+ 0.00000000e+00 0.00000000e+00 0.00000000e+00 0.00000000e+00 3.96831067e+00
+ 0.00000000e+00 0.00000000e+00 0.00000000e+00 0.00000000e+00 0.00000000e+00 3.96831067e+00
+ Go=
+ 0.00000000e+00
+ -0.00000000e+00 0.00000000e+00
+ -0.00000000e+00 -0.00000000e+00 0.00000000e+00
+ -0.00000000e+00 -0.00000000e+00 -0.00000000e+00 0.00000000e+00
+ -0.00000000e+00 -0.00000000e+00 -0.00000000e+00 -0.00000000e+00 0.00000000e+00
+ -0.00000000e+00 -0.00000000e+00 -0.00000000e+00 -0.00000000e+00 -0.00000000e+00 0.00000000e+00
+ Rs=
+ 1.55902417e-03
+ -0.00000000e+00 1.55902417e-03
+ -0.00000000e+00 -0.00000000e+00 1.55902417e-03
+ -0.00000000e+00 -0.00000000e+00 -0.00000000e+00 1.55902417e-03
+ -0.00000000e+00 -0.00000000e+00 -0.00000000e+00 -0.00000000e+00 1.55902417e-03
+ -0.00000000e+00 -0.00000000e+00 -0.00000000e+00 -0.00000000e+00 -0.00000000e+00 1.55902417e-03
+ Gd=
+ 2.03818458e-11
+ -1.79694673e-13 2.03594940e-11
+ -0.00000000e+00 -1.68761202e-13 2.03586342e-11
+ -0.00000000e+00 -0.00000000e+00 -1.92124436e-13 2.03576063e-11
+ -0.00000000e+00 -0.00000000e+00 -0.00000000e+00 -2.00457887e-13 2.03581933e-11
+ -0.00000000e+00 -0.00000000e+00 -0.00000000e+00 -0.00000000e+00 -1.87871327e-13 2.03815462e-11

.Model Wmodel_Trace2611_Auto_115::MIPI_DSI0_DATA2_P W MODELTYPE=RLGC N=1
+ Lo=
+ 3.32029740e-07
+ Co=
+ 1.03489020e-10
+ Ro=
+ 3.96831067e+00
+ Go=
+ 0.00000000e+00
+ Rs=
+ 1.55902417e-03
+ Gd=
+ 2.04067990e-11

.Model Wmodel_Trace2611_Auto_119::MIPI_DSI0_DATA2_P W MODELTYPE=RLGC N=2
+ Lo=
+ 3.30714915e-07
+ 4.26278812e-08 3.30714915e-07
+ Co=
+ 1.03818763e-10
+ -4.60017723e-12 1.03818763e-10
+ Ro=
+ 3.96831067e+00
+ 0.00000000e+00 3.96831067e+00
+ Go=
+ 0.00000000e+00
+ -0.00000000e+00 0.00000000e+00
+ Rs=
+ 1.55902417e-03
+ -0.00000000e+00 1.55902417e-03
+ Gd=
+ 2.03824526e-11
+ -1.83124153e-13 2.03824526e-11

.Model Wmodel_Trace2611_Auto_120::MIPI_DSI0_DATA2_P W MODELTYPE=RLGC N=1
+ Lo=
+ 3.32029740e-07
+ Co=
+ 1.03489020e-10
+ Ro=
+ 3.96831067e+00
+ Go=
+ 0.00000000e+00
+ Rs=
+ 1.55902417e-03
+ Gd=
+ 2.04067990e-11

.Model Wmodel_Trace2615::MIPI_DSI0_DATA2_P W MODELTYPE=RLGC N=1
+ Lo=
+ 3.32029740e-07
+ Co=
+ 1.03489020e-10
+ Ro=
+ 3.96831067e+00
+ Go=
+ 0.00000000e+00
+ Rs=
+ 1.55902417e-03
+ Gd=
+ 2.04067990e-11

.Model Wmodel_Trace2617::MIPI_DSI0_DATA2_P W MODELTYPE=RLGC N=1
+ Lo=
+ 3.32029740e-07
+ Co=
+ 1.03489020e-10
+ Ro=
+ 3.96831067e+00
+ Go=
+ 0.00000000e+00
+ Rs=
+ 1.55902417e-03
+ Gd=
+ 2.04067990e-11

.Model Wmodel_Trace2617_Auto_103::MIPI_DSI0_DATA2_P W MODELTYPE=RLGC N=1
+ Lo=
+ 3.32029740e-07
+ Co=
+ 1.03489020e-10
+ Ro=
+ 3.96831067e+00
+ Go=
+ 0.00000000e+00
+ Rs=
+ 1.55902417e-03
+ Gd=
+ 2.04067990e-11

.Model Wmodel_Trace2621::MIPI_DSI0_DATA2_P W MODELTYPE=RLGC N=1
+ Lo=
+ 3.32029740e-07
+ Co=
+ 1.03489020e-10
+ Ro=
+ 3.96831067e+00
+ Go=
+ 0.00000000e+00
+ Rs=
+ 1.55902417e-03
+ Gd=
+ 2.04067990e-11

.Model Wmodel_Trace2623_Auto_105::MIPI_DSI0_DATA2_P W MODELTYPE=RLGC N=3
+ Lo=
+ 3.30700752e-07
+ 4.15492032e-08 3.29506202e-07
+ 1.18805025e-08 4.18769793e-08 3.30677456e-07
+ Co=
+ 1.03805429e-10
+ -4.42817432e-12 1.04113701e-10
+ -5.39638913e-13 -4.48353292e-12 1.03812942e-10
+ Ro=
+ 3.96831067e+00
+ 0.00000000e+00 3.96831067e+00
+ 0.00000000e+00 0.00000000e+00 3.96831067e+00
+ Go=
+ 0.00000000e+00
+ -0.00000000e+00 0.00000000e+00
+ -0.00000000e+00 -0.00000000e+00 0.00000000e+00
+ Rs=
+ 1.55902417e-03
+ -0.00000000e+00 1.55902417e-03
+ -0.00000000e+00 -0.00000000e+00 1.55902417e-03
+ Gd=
+ 2.03822251e-11
+ -1.73930869e-13 2.03599307e-11
+ -0.00000000e+00 -1.79391374e-13 2.03820272e-11

.Model Wmodel_Trace2632::MIPI_DSI0_DATA2_P W MODELTYPE=RLGC N=1
+ Lo=
+ 3.32029740e-07
+ Co=
+ 1.03489020e-10
+ Ro=
+ 3.96831067e+00
+ Go=
+ 0.00000000e+00
+ Rs=
+ 1.55902417e-03
+ Gd=
+ 2.04067990e-11

.Model Wmodel_Trace2634_Auto_107::MIPI_DSI0_DATA2_P W MODELTYPE=RLGC N=2
+ Lo=
+ 3.30748904e-07
+ 4.21593990e-08 3.30748904e-07
+ Co=
+ 1.03807716e-10
+ -4.52055469e-12 1.03807716e-10
+ Ro=
+ 3.96831067e+00
+ 0.00000000e+00 3.96831067e+00
+ Go=
+ 0.00000000e+00
+ -0.00000000e+00 0.00000000e+00
+ Rs=
+ 1.55902417e-03
+ -0.00000000e+00 1.55902417e-03
+ Gd=
+ 2.03827260e-11
+ -1.75097034e-13 2.03827260e-11

.Model Wmodel_Trace2636::MIPI_DSI0_DATA2_P W MODELTYPE=RLGC N=1
+ Lo=
+ 3.32029740e-07
+ Co=
+ 1.03489020e-10
+ Ro=
+ 3.96831067e+00
+ Go=
+ 0.00000000e+00
+ Rs=
+ 1.55902417e-03
+ Gd=
+ 2.04067990e-11

.Model Wmodel_Trace2638::MIPI_DSI0_DATA2_P W MODELTYPE=RLGC N=1
+ Lo=
+ 3.32029740e-07
+ Co=
+ 1.03489020e-10
+ Ro=
+ 3.96831067e+00
+ Go=
+ 0.00000000e+00
+ Rs=
+ 1.55902417e-03
+ Gd=
+ 2.04067990e-11

.Model Wmodel_Trace2638_Auto_382::MIPI_DSI0_DATA2_P W MODELTYPE=RLGC N=1
+ Lo=
+ 3.32029740e-07
+ Co=
+ 1.03489020e-10
+ Ro=
+ 3.96831067e+00
+ Go=
+ 0.00000000e+00
+ Rs=
+ 1.55902417e-03
+ Gd=
+ 2.04067990e-11

.Model Wmodel_Trace2640::MIPI_DSI0_DATA2_P W MODELTYPE=RLGC N=1
+ Lo=
+ 3.32029740e-07
+ Co=
+ 1.03489020e-10
+ Ro=
+ 3.96831067e+00
+ Go=
+ 0.00000000e+00
+ Rs=
+ 1.55902417e-03
+ Gd=
+ 2.04067990e-11

.Model Wmodel_Trace2644_Auto_244::MIPI_DSI0_DATA2_P W MODELTYPE=RLGC N=1
+ Lo=
+ 3.58484574e-07
+ Co=
+ 9.37055974e-11
+ Ro=
+ 4.84133902e+00
+ Go=
+ 0.00000000e+00
+ Rs=
+ 1.72420198e-03
+ Gd=
+ 1.82370500e-11

.Model Wmodel_Trace2645::MIPI_DSI0_DATA2_P W MODELTYPE=RLGC N=1
+ Lo=
+ 3.58484574e-07
+ Co=
+ 9.37055974e-11
+ Ro=
+ 4.84133902e+00
+ Go=
+ 0.00000000e+00
+ Rs=
+ 1.72420198e-03
+ Gd=
+ 1.82370500e-11

.Model Wmodel_Trace2647::MIPI_DSI0_DATA2_P W MODELTYPE=RLGC N=1
+ Lo=
+ 3.32029740e-07
+ Co=
+ 1.03489020e-10
+ Ro=
+ 3.96831067e+00
+ Go=
+ 0.00000000e+00
+ Rs=
+ 1.55902417e-03
+ Gd=
+ 2.04067990e-11

.Model Wmodel_Trace2647_Auto_248::MIPI_DSI0_DATA2_P W MODELTYPE=RLGC N=3
+ Lo=
+ 3.30726346e-07
+ 4.12005758e-08 3.29530752e-07
+ 1.18208195e-08 4.18812577e-08 3.30678252e-07
+ Co=
+ 1.03797443e-10
+ -4.36946769e-12 1.04105832e-10
+ -5.37727802e-13 -4.48410579e-12 1.03812903e-10
+ Ro=
+ 3.96831067e+00
+ 0.00000000e+00 3.96831067e+00
+ 0.00000000e+00 0.00000000e+00 3.96831067e+00
+ Go=
+ 0.00000000e+00
+ -0.00000000e+00 0.00000000e+00
+ -0.00000000e+00 -0.00000000e+00 0.00000000e+00
+ Rs=
+ 1.55902417e-03
+ -0.00000000e+00 1.55902417e-03
+ -0.00000000e+00 -0.00000000e+00 1.55902417e-03
+ Gd=
+ 2.03824488e-11
+ -1.68081720e-13 2.03601366e-11
+ -0.00000000e+00 -1.79345950e-13 2.03820310e-11

.Model Wmodel_Trace2648::MIPI_DSI0_DATA2_P W MODELTYPE=RLGC N=1
+ Lo=
+ 3.32029740e-07
+ Co=
+ 1.03489020e-10
+ Ro=
+ 3.96831067e+00
+ Go=
+ 0.00000000e+00
+ Rs=
+ 1.55902417e-03
+ Gd=
+ 2.04067990e-11

.Model Wmodel_Trace2650::MIPI_DSI0_DATA2_P W MODELTYPE=RLGC N=1
+ Lo=
+ 3.32029740e-07
+ Co=
+ 1.03489020e-10
+ Ro=
+ 3.96831067e+00
+ Go=
+ 0.00000000e+00
+ Rs=
+ 1.55902417e-03
+ Gd=
+ 2.04067990e-11

.Model Wmodel_Trace2660::MIPI_DSI0_DATA2_P W MODELTYPE=RLGC N=1
+ Lo=
+ 3.32029740e-07
+ Co=
+ 1.03489020e-10
+ Ro=
+ 3.96831067e+00
+ Go=
+ 0.00000000e+00
+ Rs=
+ 1.55902417e-03
+ Gd=
+ 2.04067990e-11

.Model Wmodel_Trace2662::MIPI_DSI0_DATA2_P W MODELTYPE=RLGC N=2
+ Lo=
+ 3.30680783e-07
+ 4.30911130e-08 3.30680783e-07
+ Co=
+ 1.03829953e-10
+ -4.67949380e-12 1.03829953e-10
+ Ro=
+ 3.96831067e+00
+ 0.00000000e+00 3.96831067e+00
+ Go=
+ 0.00000000e+00
+ -0.00000000e+00 0.00000000e+00
+ Rs=
+ 1.55902417e-03
+ -0.00000000e+00 1.55902417e-03
+ Gd=
+ 2.03821957e-11
+ -1.91198666e-13 2.03821957e-11

.Model Wmodel_Trace2663::MIPI_DSI0_DATA2_P W MODELTYPE=RLGC N=1
+ Lo=
+ 3.32029740e-07
+ Co=
+ 1.03489020e-10
+ Ro=
+ 3.96831067e+00
+ Go=
+ 0.00000000e+00
+ Rs=
+ 1.55902417e-03
+ Gd=
+ 2.04067990e-11

.Model Wmodel_Trace2666::MIPI_DSI0_DATA2_P W MODELTYPE=RLGC N=1
+ Lo=
+ 3.32029740e-07
+ Co=
+ 1.03489020e-10
+ Ro=
+ 3.96831067e+00
+ Go=
+ 0.00000000e+00
+ Rs=
+ 1.55902417e-03
+ Gd=
+ 2.04067990e-11

.Model Wmodel_Trace2667::MIPI_DSI0_DATA2_P W MODELTYPE=RLGC N=1
+ Lo=
+ 3.32029740e-07
+ Co=
+ 1.03489020e-10
+ Ro=
+ 3.96831067e+00
+ Go=
+ 0.00000000e+00
+ Rs=
+ 1.55902417e-03
+ Gd=
+ 2.04067990e-11

.Model Wmodel_Trace2669::MIPI_DSI0_DATA2_P W MODELTYPE=RLGC N=1
+ Lo=
+ 3.32029740e-07
+ Co=
+ 1.03489020e-10
+ Ro=
+ 3.96831067e+00
+ Go=
+ 0.00000000e+00
+ Rs=
+ 1.55902417e-03
+ Gd=
+ 2.04067990e-11
