*Wmodel Definition*
*TraceModel Definition*

.Model Wmodel_Trace1976::MIPI_DSI0_CLK_N W MODELTYPE=RLGC N=1
+ Lo=
+ 3.32029740e-07
+ Co=
+ 1.03489020e-10
+ Ro=
+ 3.96831067e+00
+ Go=
+ 0.00000000e+00
+ Rs=
+ 1.55902417e-03
+ Gd=
+ 2.04067990e-11

.Model Wmodel_Trace1977::MIPI_DSI0_CLK_N W MODELTYPE=RLGC N=1
+ Lo=
+ 3.32029740e-07
+ Co=
+ 1.03489020e-10
+ Ro=
+ 3.96831067e+00
+ Go=
+ 0.00000000e+00
+ Rs=
+ 1.55902417e-03
+ Gd=
+ 2.04067990e-11

.Model Wmodel_Trace1977_Auto_1542::MIPI_DSI0_CLK_N W MODELTYPE=RLGC N=1
+ Lo=
+ 3.32029740e-07
+ Co=
+ 1.03489020e-10
+ Ro=
+ 3.96831067e+00
+ Go=
+ 0.00000000e+00
+ Rs=
+ 1.55902417e-03
+ Gd=
+ 2.04067990e-11

.Model Wmodel_Trace1977_Auto_1591::MIPI_DSI0_CLK_N W MODELTYPE=RLGC N=1
+ Lo=
+ 3.32029740e-07
+ Co=
+ 1.03489020e-10
+ Ro=
+ 3.96831067e+00
+ Go=
+ 0.00000000e+00
+ Rs=
+ 1.55902417e-03
+ Gd=
+ 2.04067990e-11

.Model Wmodel_Trace1977_Auto_1594::MIPI_DSI0_CLK_N W MODELTYPE=RLGC N=3
+ Lo=
+ 3.30902545e-07
+ 3.86814007e-08 3.29699183e-07
+ 1.13829695e-08 4.19162010e-08 3.30683576e-07
+ Co=
+ 1.03743990e-10
+ -3.95538497e-12 1.04053333e-10
+ -5.23349804e-13 -4.48897379e-12 1.03812731e-10
+ Ro=
+ 3.96831067e+00
+ 0.00000000e+00 3.96831067e+00
+ 0.00000000e+00 0.00000000e+00 3.96831067e+00
+ Go=
+ 0.00000000e+00
+ -0.00000000e+00 0.00000000e+00
+ -0.00000000e+00 -0.00000000e+00 0.00000000e+00
+ Rs=
+ 1.55902417e-03
+ -0.00000000e+00 1.55902417e-03
+ -0.00000000e+00 -0.00000000e+00 1.55902417e-03
+ Gd=
+ 2.03842523e-11
+ -1.28181170e-13 2.03618087e-11
+ -0.00000000e+00 -1.79098689e-13 2.03820564e-11

.Model Wmodel_Trace1978::MIPI_DSI0_CLK_N W MODELTYPE=RLGC N=1
+ Lo=
+ 3.32029740e-07
+ Co=
+ 1.03489020e-10
+ Ro=
+ 3.96831067e+00
+ Go=
+ 0.00000000e+00
+ Rs=
+ 1.55902417e-03
+ Gd=
+ 2.04067990e-11

.Model Wmodel_Trace1978_Auto_1528::MIPI_DSI0_CLK_N W MODELTYPE=RLGC N=1
+ Lo=
+ 3.32029740e-07
+ Co=
+ 1.03489020e-10
+ Ro=
+ 3.96831067e+00
+ Go=
+ 0.00000000e+00
+ Rs=
+ 1.55902417e-03
+ Gd=
+ 2.04067990e-11

.Model Wmodel_Trace1978_Auto_1529::MIPI_DSI0_CLK_N W MODELTYPE=RLGC N=2
+ Lo=
+ 3.29498423e-07
+ 5.60958798e-08 3.29498423e-07
+ Co=
+ 1.04267274e-10
+ -7.13373043e-12 1.04267274e-10
+ Ro=
+ 3.96831067e+00
+ 0.00000000e+00 3.96831067e+00
+ Go=
+ 0.00000000e+00
+ -0.00000000e+00 0.00000000e+00
+ Rs=
+ 1.55902417e-03
+ -0.00000000e+00 1.55902417e-03
+ Gd=
+ 2.03830264e-11
+ -4.70479520e-13 2.03830264e-11

.Model Wmodel_Trace1978_Auto_1530::MIPI_DSI0_CLK_N W MODELTYPE=RLGC N=1
+ Lo=
+ 3.32029740e-07
+ Co=
+ 1.03489020e-10
+ Ro=
+ 3.96831067e+00
+ Go=
+ 0.00000000e+00
+ Rs=
+ 1.55902417e-03
+ Gd=
+ 2.04067990e-11

.Model Wmodel_Trace1978_Auto_1532::MIPI_DSI0_CLK_N W MODELTYPE=RLGC N=1
+ Lo=
+ 3.32029740e-07
+ Co=
+ 1.03489020e-10
+ Ro=
+ 3.96831067e+00
+ Go=
+ 0.00000000e+00
+ Rs=
+ 1.55902417e-03
+ Gd=
+ 2.04067990e-11

.Model Wmodel_Trace1978_Auto_1534::MIPI_DSI0_CLK_N W MODELTYPE=RLGC N=1
+ Lo=
+ 3.32029740e-07
+ Co=
+ 1.03489020e-10
+ Ro=
+ 3.96831067e+00
+ Go=
+ 0.00000000e+00
+ Rs=
+ 1.55902417e-03
+ Gd=
+ 2.04067990e-11

.Model Wmodel_Trace1978_Auto_1536::MIPI_DSI0_CLK_N W MODELTYPE=RLGC N=1
+ Lo=
+ 3.32029740e-07
+ Co=
+ 1.03489020e-10
+ Ro=
+ 3.96831067e+00
+ Go=
+ 0.00000000e+00
+ Rs=
+ 1.55902417e-03
+ Gd=
+ 2.04067990e-11

.Model Wmodel_Trace1989::MIPI_DSI0_CLK_N W MODELTYPE=RLGC N=1
+ Lo=
+ 3.32029740e-07
+ Co=
+ 1.03489020e-10
+ Ro=
+ 3.96831067e+00
+ Go=
+ 0.00000000e+00
+ Rs=
+ 1.55902417e-03
+ Gd=
+ 2.04067990e-11

.Model Wmodel_Trace2002::MIPI_DSI0_CLK_N W MODELTYPE=RLGC N=1
+ Lo=
+ 3.32029740e-07
+ Co=
+ 1.03489020e-10
+ Ro=
+ 3.96831067e+00
+ Go=
+ 0.00000000e+00
+ Rs=
+ 1.55902417e-03
+ Gd=
+ 2.04067990e-11

.Model Wmodel_Trace2003::MIPI_DSI0_CLK_N W MODELTYPE=RLGC N=4
+ Lo=
+ 3.30647663e-07
+ 4.17590103e-08 3.28880305e-07
+ 1.28887719e-08 4.80414125e-08 3.28880305e-07
+ 5.51279151e-09 1.28887719e-08 4.17590103e-08 3.30647663e-07
+ Co=
+ 1.03814840e-10
+ -4.47009205e-12 1.04304506e-10
+ -5.56912541e-13 -5.60173472e-12 1.04304506e-10
+ -2.43482194e-13 -5.56912541e-13 -4.47009205e-12 1.03814840e-10
+ Ro=
+ 3.96831067e+00
+ 0.00000000e+00 3.96831067e+00
+ 0.00000000e+00 0.00000000e+00 3.96831067e+00
+ 0.00000000e+00 0.00000000e+00 0.00000000e+00 3.96831067e+00
+ Go=
+ 0.00000000e+00
+ -0.00000000e+00 0.00000000e+00
+ -0.00000000e+00 -0.00000000e+00 0.00000000e+00
+ -0.00000000e+00 -0.00000000e+00 -0.00000000e+00 0.00000000e+00
+ Rs=
+ 1.55902417e-03
+ -0.00000000e+00 1.55902417e-03
+ -0.00000000e+00 -0.00000000e+00 1.55902417e-03
+ -0.00000000e+00 -0.00000000e+00 -0.00000000e+00 1.55902417e-03
+ Gd=
+ 2.03818160e-11
+ -1.80651019e-13 2.03569609e-11
+ -0.00000000e+00 -3.07759839e-13 2.03569609e-11
+ -0.00000000e+00 -0.00000000e+00 -1.80651019e-13 2.03818160e-11

.Model Wmodel_Trace2003_Auto_287::MIPI_DSI0_CLK_N W MODELTYPE=RLGC N=3
+ Lo=
+ 3.30661161e-07
+ 4.17923379e-08 3.28966317e-07
+ 1.30026133e-08 4.83558306e-08 3.30140000e-07
+ Co=
+ 1.03813776e-10
+ -4.47252057e-12 1.04298938e-10
+ -5.73390430e-13 -5.64033823e-12 1.03992890e-10
+ Ro=
+ 3.96831067e+00
+ 0.00000000e+00 3.96831067e+00
+ 0.00000000e+00 0.00000000e+00 3.96831067e+00
+ Go=
+ 0.00000000e+00
+ -0.00000000e+00 0.00000000e+00
+ -0.00000000e+00 -0.00000000e+00 0.00000000e+00
+ Rs=
+ 1.55902417e-03
+ -0.00000000e+00 1.55902417e-03
+ -0.00000000e+00 -0.00000000e+00 1.55902417e-03
+ Gd=
+ 2.03819593e-11
+ -1.80335438e-13 2.03576581e-11
+ -0.00000000e+00 -3.03475307e-13 2.03796108e-11

.Model Wmodel_Trace2003_Auto_293::MIPI_DSI0_CLK_N W MODELTYPE=RLGC N=2
+ Lo=
+ 3.30748548e-07
+ 4.21643423e-08 3.30748548e-07
+ Co=
+ 1.03807831e-10
+ -4.52139172e-12 1.03807831e-10
+ Ro=
+ 3.96831067e+00
+ 0.00000000e+00 3.96831067e+00
+ Go=
+ 0.00000000e+00
+ -0.00000000e+00 0.00000000e+00
+ Rs=
+ 1.55902417e-03
+ -0.00000000e+00 1.55902417e-03
+ Gd=
+ 2.03827231e-11
+ -1.75181003e-13 2.03827231e-11

.Model Wmodel_Trace2008::MIPI_DSI0_CLK_N W MODELTYPE=RLGC N=1
+ Lo=
+ 3.32029740e-07
+ Co=
+ 1.03489020e-10
+ Ro=
+ 3.96831067e+00
+ Go=
+ 0.00000000e+00
+ Rs=
+ 1.55902417e-03
+ Gd=
+ 2.04067990e-11

.Model Wmodel_Trace2010::MIPI_DSI0_CLK_N W MODELTYPE=RLGC N=2
+ Lo=
+ 3.31623945e-07
+ 2.57991533e-08 3.31623945e-07
+ Co=
+ 1.03563508e-10
+ -2.13804211e-12 1.03563508e-10
+ Ro=
+ 3.96831067e+00
+ 0.00000000e+00 3.96831067e+00
+ Go=
+ 0.00000000e+00
+ -0.00000000e+00 0.00000000e+00
+ Rs=
+ 1.55902417e-03
+ -0.00000000e+00 1.55902417e-03
+ Gd=
+ 2.03963423e-11
+ -0.00000000e+00 2.03963423e-11

.Model Wmodel_Trace2019::MIPI_DSI0_CLK_N W MODELTYPE=RLGC N=1
+ Lo=
+ 3.32029740e-07
+ Co=
+ 1.03489020e-10
+ Ro=
+ 3.96831067e+00
+ Go=
+ 0.00000000e+00
+ Rs=
+ 1.55902417e-03
+ Gd=
+ 2.04067990e-11

.Model Wmodel_Trace2025::MIPI_DSI0_CLK_N W MODELTYPE=RLGC N=1
+ Lo=
+ 3.32029740e-07
+ Co=
+ 1.03489020e-10
+ Ro=
+ 3.96831067e+00
+ Go=
+ 0.00000000e+00
+ Rs=
+ 1.55902417e-03
+ Gd=
+ 2.04067990e-11

.Model Wmodel_Trace2031::MIPI_DSI0_CLK_N W MODELTYPE=RLGC N=1
+ Lo=
+ 3.32029740e-07
+ Co=
+ 1.03489020e-10
+ Ro=
+ 3.96831067e+00
+ Go=
+ 0.00000000e+00
+ Rs=
+ 1.55902417e-03
+ Gd=
+ 2.04067990e-11

.Model Wmodel_Trace2033::MIPI_DSI0_CLK_N W MODELTYPE=RLGC N=1
+ Lo=
+ 3.32029740e-07
+ Co=
+ 1.03489020e-10
+ Ro=
+ 3.96831067e+00
+ Go=
+ 0.00000000e+00
+ Rs=
+ 1.55902417e-03
+ Gd=
+ 2.04067990e-11

.Model Wmodel_Trace2033_Auto_212::MIPI_DSI0_CLK_N W MODELTYPE=RLGC N=4
+ Lo=
+ 3.30657942e-07
+ 4.25945798e-08 3.30221966e-07
+ 9.07572744e-09 2.65975389e-08 3.30222652e-07
+ 4.38926525e-09 9.07464789e-09 4.25850756e-08 3.30658651e-07
+ Co=
+ 1.03825618e-10
+ -4.60176365e-12 1.03907326e-10
+ -4.27072955e-13 -2.22627735e-12 1.03907100e-10
+ -1.96988410e-13 -4.27033576e-13 -4.60013800e-12 1.03825389e-10
+ Ro=
+ 3.96831067e+00
+ 0.00000000e+00 3.96831067e+00
+ 0.00000000e+00 0.00000000e+00 3.96831067e+00
+ 0.00000000e+00 0.00000000e+00 0.00000000e+00 3.96831067e+00
+ Go=
+ 0.00000000e+00
+ -0.00000000e+00 0.00000000e+00
+ -0.00000000e+00 -0.00000000e+00 0.00000000e+00
+ -0.00000000e+00 -0.00000000e+00 -0.00000000e+00 0.00000000e+00
+ Rs=
+ 1.55902417e-03
+ -0.00000000e+00 1.55902417e-03
+ -0.00000000e+00 -0.00000000e+00 1.55902417e-03
+ -0.00000000e+00 -0.00000000e+00 -0.00000000e+00 1.55902417e-03
+ Gd=
+ 2.03817897e-11
+ -1.87636815e-13 2.03709896e-11
+ -0.00000000e+00 -2.05057053e-15 2.03709947e-11
+ -0.00000000e+00 -0.00000000e+00 -1.87471505e-13 2.03817951e-11

.Model Wmodel_Trace2033_Auto_214::MIPI_DSI0_CLK_N W MODELTYPE=RLGC N=1
+ Lo=
+ 3.32029740e-07
+ Co=
+ 1.03489020e-10
+ Ro=
+ 3.96831067e+00
+ Go=
+ 0.00000000e+00
+ Rs=
+ 1.55902417e-03
+ Gd=
+ 2.04067990e-11

.Model Wmodel_Trace2035::MIPI_DSI0_CLK_N W MODELTYPE=RLGC N=1
+ Lo=
+ 3.32029740e-07
+ Co=
+ 1.03489020e-10
+ Ro=
+ 3.96831067e+00
+ Go=
+ 0.00000000e+00
+ Rs=
+ 1.55902417e-03
+ Gd=
+ 2.04067990e-11

.Model Wmodel_Trace2040::MIPI_DSI0_CLK_N W MODELTYPE=RLGC N=2
+ Lo=
+ 3.31626495e-07
+ 2.57288458e-08 3.31626495e-07
+ Co=
+ 1.03562938e-10
+ -2.12956892e-12 1.03562938e-10
+ Ro=
+ 3.96831067e+00
+ 0.00000000e+00 3.96831067e+00
+ Go=
+ 0.00000000e+00
+ -0.00000000e+00 0.00000000e+00
+ Rs=
+ 1.55902417e-03
+ -0.00000000e+00 1.55902417e-03
+ Gd=
+ 2.03964015e-11
+ -0.00000000e+00 2.03964015e-11

.Model Wmodel_Trace2040_Auto_195::MIPI_DSI0_CLK_N W MODELTYPE=RLGC N=1
+ Lo=
+ 3.32029740e-07
+ Co=
+ 1.03489020e-10
+ Ro=
+ 3.96831067e+00
+ Go=
+ 0.00000000e+00
+ Rs=
+ 1.55902417e-03
+ Gd=
+ 2.04067990e-11

.Model Wmodel_Trace2042::MIPI_DSI0_CLK_N W MODELTYPE=RLGC N=1
+ Lo=
+ 3.32029740e-07
+ Co=
+ 1.03489020e-10
+ Ro=
+ 3.96831067e+00
+ Go=
+ 0.00000000e+00
+ Rs=
+ 1.55902417e-03
+ Gd=
+ 2.04067990e-11

.Model Wmodel_Trace2043_Auto_209::MIPI_DSI0_CLK_N W MODELTYPE=RLGC N=1
+ Lo=
+ 3.32029740e-07
+ Co=
+ 1.03489020e-10
+ Ro=
+ 3.96831067e+00
+ Go=
+ 0.00000000e+00
+ Rs=
+ 1.55902417e-03
+ Gd=
+ 2.04067990e-11

.Model Wmodel_Trace2043_Auto_217::MIPI_DSI0_CLK_N W MODELTYPE=RLGC N=1
+ Lo=
+ 3.32029740e-07
+ Co=
+ 1.03489020e-10
+ Ro=
+ 3.96831067e+00
+ Go=
+ 0.00000000e+00
+ Rs=
+ 1.55902417e-03
+ Gd=
+ 2.04067990e-11

.Model Wmodel_Trace2048::MIPI_DSI0_CLK_N W MODELTYPE=RLGC N=1
+ Lo=
+ 3.32029740e-07
+ Co=
+ 1.03489020e-10
+ Ro=
+ 3.96831067e+00
+ Go=
+ 0.00000000e+00
+ Rs=
+ 1.55902417e-03
+ Gd=
+ 2.04067990e-11

.Model Wmodel_Trace2050_Auto_197::MIPI_DSI0_CLK_N W MODELTYPE=RLGC N=1
+ Lo=
+ 3.32029740e-07
+ Co=
+ 1.03489020e-10
+ Ro=
+ 3.96831067e+00
+ Go=
+ 0.00000000e+00
+ Rs=
+ 1.55902417e-03
+ Gd=
+ 2.04067990e-11

.Model Wmodel_Trace2051::MIPI_DSI0_CLK_N W MODELTYPE=RLGC N=3
+ Lo=
+ 3.56708694e-07
+ 5.36779816e-08 3.56103431e-07
+ 1.25874791e-08 3.59167959e-08 3.57739431e-07
+ Co=
+ 9.41789023e-11
+ -5.38734042e-12 9.43105412e-11
+ -4.88566505e-13 -2.86104971e-12 9.38505678e-11
+ Ro=
+ 4.84133902e+00
+ 0.00000000e+00 4.84133902e+00
+ 0.00000000e+00 0.00000000e+00 4.84133902e+00
+ Go=
+ 0.00000000e+00
+ -0.00000000e+00 0.00000000e+00
+ -0.00000000e+00 -0.00000000e+00 0.00000000e+00
+ Rs=
+ 1.72420198e-03
+ -0.00000000e+00 1.72420198e-03
+ -0.00000000e+00 -0.00000000e+00 1.72420198e-03
+ Gd=
+ 1.82119609e-11
+ -2.97373037e-13 1.81979010e-11
+ -0.00000000e+00 -5.26909945e-14 1.82207988e-11

.Model Wmodel_Trace2051_Auto_1014::MIPI_DSI0_CLK_N W MODELTYPE=RLGC N=1
+ Lo=
+ 3.58484574e-07
+ Co=
+ 9.37055974e-11
+ Ro=
+ 4.84133902e+00
+ Go=
+ 0.00000000e+00
+ Rs=
+ 1.72420198e-03
+ Gd=
+ 1.82370500e-11

.Model Wmodel_Trace2051_Auto_1021::MIPI_DSI0_CLK_N W MODELTYPE=RLGC N=4
+ Lo=
+ 3.55933471e-07
+ 6.26664344e-08 3.55353395e-07
+ 1.33435178e-08 3.45905691e-08 3.56862228e-07
+ 5.68066057e-09 1.05145541e-08 4.10766452e-08 3.57508559e-07
+ Co=
+ 9.44706889e-11
+ -6.90663002e-12 9.45917241e-11
+ -4.95043850e-13 -2.69615440e-12 9.40437364e-11
+ -2.05055541e-13 -4.11389469e-13 -3.52935257e-12 9.39171145e-11
+ Ro=
+ 4.84133902e+00
+ 0.00000000e+00 4.84133902e+00
+ 0.00000000e+00 0.00000000e+00 4.84133902e+00
+ 0.00000000e+00 0.00000000e+00 0.00000000e+00 4.84133902e+00
+ Go=
+ 0.00000000e+00
+ -0.00000000e+00 0.00000000e+00
+ -0.00000000e+00 -0.00000000e+00 0.00000000e+00
+ -0.00000000e+00 -0.00000000e+00 -0.00000000e+00 0.00000000e+00
+ Rs=
+ 1.72420198e-03
+ -0.00000000e+00 1.72420198e-03
+ -0.00000000e+00 -0.00000000e+00 1.72420198e-03
+ -0.00000000e+00 -0.00000000e+00 -0.00000000e+00 1.72420198e-03
+ Gd=
+ 1.82149816e-11
+ -4.78535437e-13 1.82015826e-11
+ -0.00000000e+00 -4.68314397e-14 1.82029562e-11
+ -0.00000000e+00 -0.00000000e+00 -1.05586019e-13 1.82171738e-11

.Model Wmodel_Trace2055::MIPI_DSI0_CLK_N W MODELTYPE=RLGC N=1
+ Lo=
+ 3.58484574e-07
+ Co=
+ 9.37055974e-11
+ Ro=
+ 4.84133902e+00
+ Go=
+ 0.00000000e+00
+ Rs=
+ 1.72420198e-03
+ Gd=
+ 1.82370500e-11

.Model Wmodel_Trace2074::MIPI_DSI0_DATA2_N W MODELTYPE=RLGC N=1
+ Lo=
+ 3.32029740e-07
+ Co=
+ 1.03489020e-10
+ Ro=
+ 3.96831067e+00
+ Go=
+ 0.00000000e+00
+ Rs=
+ 1.55902417e-03
+ Gd=
+ 2.04067990e-11

.Model Wmodel_Trace2074_Auto_1397::MIPI_DSI0_DATA2_N W MODELTYPE=RLGC N=2
+ Lo=
+ 3.31139019e-07
+ 3.61466742e-08 3.31139019e-07
+ Co=
+ 1.03688370e-10
+ -3.55292892e-12 1.03688370e-10
+ Ro=
+ 3.96831067e+00
+ 0.00000000e+00 3.96831067e+00
+ Go=
+ 0.00000000e+00
+ -0.00000000e+00 0.00000000e+00
+ Rs=
+ 1.55902417e-03
+ -0.00000000e+00 1.55902417e-03
+ Gd=
+ 2.03871797e-11
+ -8.47952296e-14 2.03871797e-11

.Model Wmodel_Trace2076::MIPI_DSI0_DATA2_N W MODELTYPE=RLGC N=1
+ Lo=
+ 3.32029740e-07
+ Co=
+ 1.03489020e-10
+ Ro=
+ 3.96831067e+00
+ Go=
+ 0.00000000e+00
+ Rs=
+ 1.55902417e-03
+ Gd=
+ 2.04067990e-11

.Model Wmodel_Trace2077#BP0::MIPI_DSI0_DATA2_N W MODELTYPE=RLGC N=2
+ Lo=
+ 3.31798463e-07
+ 2.01898470e-08 3.31798463e-07
+ Co=
+ 1.03527119e-10
+ -1.51193913e-12 1.03527119e-10
+ Ro=
+ 3.96831067e+00
+ 0.00000000e+00 3.96831067e+00
+ Go=
+ 0.00000000e+00
+ -0.00000000e+00 0.00000000e+00
+ Rs=
+ 1.55902417e-03
+ -0.00000000e+00 1.55902417e-03
+ Gd=
+ 2.04006351e-11
+ -0.00000000e+00 2.04006351e-11

.Model Wmodel_Trace2077#BP0_Auto_1392::MIPI_DSI0_DATA2_N W MODELTYPE=RLGC N=1
+ Lo=
+ 3.32029740e-07
+ Co=
+ 1.03489020e-10
+ Ro=
+ 3.96831067e+00
+ Go=
+ 0.00000000e+00
+ Rs=
+ 1.55902417e-03
+ Gd=
+ 2.04067990e-11

.Model Wmodel_Trace2077#BP0_Auto_1400::MIPI_DSI0_DATA2_N W MODELTYPE=RLGC N=1
+ Lo=
+ 3.32029740e-07
+ Co=
+ 1.03489020e-10
+ Ro=
+ 3.96831067e+00
+ Go=
+ 0.00000000e+00
+ Rs=
+ 1.55902417e-03
+ Gd=
+ 2.04067990e-11

.Model Wmodel_Trace2081::MIPI_DSI0_DATA2_N W MODELTYPE=RLGC N=1
+ Lo=
+ 3.32029740e-07
+ Co=
+ 1.03489020e-10
+ Ro=
+ 3.96831067e+00
+ Go=
+ 0.00000000e+00
+ Rs=
+ 1.55902417e-03
+ Gd=
+ 2.04067990e-11

.Model Wmodel_Trace2083_Auto_1238::MIPI_DSI0_DATA2_N W MODELTYPE=RLGC N=2
+ Lo=
+ 3.31078363e-07
+ 3.71728283e-08 3.31078363e-07
+ Co=
+ 1.03705959e-10
+ -3.71079724e-12 1.03705959e-10
+ Ro=
+ 3.96831067e+00
+ 0.00000000e+00 3.96831067e+00
+ Go=
+ 0.00000000e+00
+ -0.00000000e+00 0.00000000e+00
+ Rs=
+ 1.55902417e-03
+ -0.00000000e+00 1.55902417e-03
+ Gd=
+ 2.03863230e-11
+ -9.85049115e-14 2.03863230e-11

.Model Wmodel_Trace2087::MIPI_DSI0_DATA2_N W MODELTYPE=RLGC N=1
+ Lo=
+ 3.32029740e-07
+ Co=
+ 1.03489020e-10
+ Ro=
+ 3.96831067e+00
+ Go=
+ 0.00000000e+00
+ Rs=
+ 1.55902417e-03
+ Gd=
+ 2.04067990e-11

.Model Wmodel_Trace2093::MIPI_DSI0_DATA2_N W MODELTYPE=RLGC N=1
+ Lo=
+ 3.32029740e-07
+ Co=
+ 1.03489020e-10
+ Ro=
+ 3.96831067e+00
+ Go=
+ 0.00000000e+00
+ Rs=
+ 1.55902417e-03
+ Gd=
+ 2.04067990e-11

.Model Wmodel_Trace2095::MIPI_DSI0_DATA2_N W MODELTYPE=RLGC N=2
+ Lo=
+ 3.30748904e-07
+ 4.21593990e-08 3.30748904e-07
+ Co=
+ 1.03807716e-10
+ -4.52055469e-12 1.03807716e-10
+ Ro=
+ 3.96831067e+00
+ 0.00000000e+00 3.96831067e+00
+ Go=
+ 0.00000000e+00
+ -0.00000000e+00 0.00000000e+00
+ Rs=
+ 1.55902417e-03
+ -0.00000000e+00 1.55902417e-03
+ Gd=
+ 2.03827260e-11
+ -1.75097034e-13 2.03827260e-11

.Model Wmodel_Trace2099::MIPI_DSI0_DATA2_N W MODELTYPE=RLGC N=1
+ Lo=
+ 3.32029740e-07
+ Co=
+ 1.03489020e-10
+ Ro=
+ 3.96831067e+00
+ Go=
+ 0.00000000e+00
+ Rs=
+ 1.55902417e-03
+ Gd=
+ 2.04067990e-11

.Model Wmodel_Trace2101_Auto_1255::MIPI_DSI0_DATA2_N W MODELTYPE=RLGC N=1
+ Lo=
+ 3.32029740e-07
+ Co=
+ 1.03489020e-10
+ Ro=
+ 3.96831067e+00
+ Go=
+ 0.00000000e+00
+ Rs=
+ 1.55902417e-03
+ Gd=
+ 2.04067990e-11

.Model Wmodel_Trace2101_Auto_1257::MIPI_DSI0_DATA2_N W MODELTYPE=RLGC N=1
+ Lo=
+ 3.32029740e-07
+ Co=
+ 1.03489020e-10
+ Ro=
+ 3.96831067e+00
+ Go=
+ 0.00000000e+00
+ Rs=
+ 1.55902417e-03
+ Gd=
+ 2.04067990e-11

.Model Wmodel_Trace2103::MIPI_DSI0_DATA2_N W MODELTYPE=RLGC N=1
+ Lo=
+ 3.32029740e-07
+ Co=
+ 1.03489020e-10
+ Ro=
+ 3.96831067e+00
+ Go=
+ 0.00000000e+00
+ Rs=
+ 1.55902417e-03
+ Gd=
+ 2.04067990e-11

.Model Wmodel_Trace2110::MIPI_DSI0_DATA2_N W MODELTYPE=RLGC N=1
+ Lo=
+ 3.32029740e-07
+ Co=
+ 1.03489020e-10
+ Ro=
+ 3.96831067e+00
+ Go=
+ 0.00000000e+00
+ Rs=
+ 1.55902417e-03
+ Gd=
+ 2.04067990e-11

.Model Wmodel_Trace2112_Auto_1260::MIPI_DSI0_DATA2_N W MODELTYPE=RLGC N=1
+ Lo=
+ 3.32029740e-07
+ Co=
+ 1.03489020e-10
+ Ro=
+ 3.96831067e+00
+ Go=
+ 0.00000000e+00
+ Rs=
+ 1.55902417e-03
+ Gd=
+ 2.04067990e-11

.Model Wmodel_Trace2112_Auto_1269::MIPI_DSI0_DATA2_N W MODELTYPE=RLGC N=1
+ Lo=
+ 3.32029740e-07
+ Co=
+ 1.03489020e-10
+ Ro=
+ 3.96831067e+00
+ Go=
+ 0.00000000e+00
+ Rs=
+ 1.55902417e-03
+ Gd=
+ 2.04067990e-11

.Model Wmodel_Trace2113::MIPI_DSI0_DATA2_N W MODELTYPE=RLGC N=1
+ Lo=
+ 3.32029740e-07
+ Co=
+ 1.03489020e-10
+ Ro=
+ 3.96831067e+00
+ Go=
+ 0.00000000e+00
+ Rs=
+ 1.55902417e-03
+ Gd=
+ 2.04067990e-11

.Model Wmodel_Trace2114::MIPI_DSI0_DATA2_N W MODELTYPE=RLGC N=3
+ Lo=
+ 3.30915367e-07
+ 3.84892013e-08 3.29711448e-07
+ 1.13489466e-08 4.19184270e-08 3.30684006e-07
+ Co=
+ 1.03740208e-10
+ -3.92453149e-12 1.04049615e-10
+ -5.22206423e-13 -4.48927357e-12 1.03812709e-10
+ Ro=
+ 3.96831067e+00
+ 0.00000000e+00 3.96831067e+00
+ 0.00000000e+00 0.00000000e+00 3.96831067e+00
+ Go=
+ 0.00000000e+00
+ -0.00000000e+00 0.00000000e+00
+ -0.00000000e+00 -0.00000000e+00 0.00000000e+00
+ Rs=
+ 1.55902417e-03
+ -0.00000000e+00 1.55902417e-03
+ -0.00000000e+00 -0.00000000e+00 1.55902417e-03
+ Gd=
+ 2.03844018e-11
+ -1.25309230e-13 2.03619484e-11
+ -0.00000000e+00 -1.79073203e-13 2.03820587e-11

.Model Wmodel_Trace2116_Auto_1559::MIPI_DSI0_DATA2_N W MODELTYPE=RLGC N=2
+ Lo=
+ 3.30365974e-07
+ 4.70669233e-08 3.30365974e-07
+ Co=
+ 1.03937432e-10
+ -5.38382626e-12 1.03937432e-10
+ Ro=
+ 3.96831067e+00
+ 0.00000000e+00 3.96831067e+00
+ Go=
+ 0.00000000e+00
+ -0.00000000e+00 0.00000000e+00
+ Rs=
+ 1.55902417e-03
+ -0.00000000e+00 1.55902417e-03
+ Gd=
+ 2.03806313e-11
+ -2.66007367e-13 2.03806313e-11

.Model Wmodel_Trace2119::MIPI_DSI0_DATA2_N W MODELTYPE=RLGC N=1
+ Lo=
+ 3.32029740e-07
+ Co=
+ 1.03489020e-10
+ Ro=
+ 3.96831067e+00
+ Go=
+ 0.00000000e+00
+ Rs=
+ 1.55902417e-03
+ Gd=
+ 2.04067990e-11

.Model Wmodel_Trace2120::MIPI_DSI0_DATA2_N W MODELTYPE=RLGC N=1
+ Lo=
+ 3.32029740e-07
+ Co=
+ 1.03489020e-10
+ Ro=
+ 3.96831067e+00
+ Go=
+ 0.00000000e+00
+ Rs=
+ 1.55902417e-03
+ Gd=
+ 2.04067990e-11

.Model Wmodel_Trace2120_Auto_1292::MIPI_DSI0_DATA2_N W MODELTYPE=RLGC N=1
+ Lo=
+ 3.32029740e-07
+ Co=
+ 1.03489020e-10
+ Ro=
+ 3.96831067e+00
+ Go=
+ 0.00000000e+00
+ Rs=
+ 1.55902417e-03
+ Gd=
+ 2.04067990e-11

.Model Wmodel_Trace2123::MIPI_DSI0_DATA2_N W MODELTYPE=RLGC N=1
+ Lo=
+ 3.58484574e-07
+ Co=
+ 9.37055974e-11
+ Ro=
+ 4.84133902e+00
+ Go=
+ 0.00000000e+00
+ Rs=
+ 1.72420198e-03
+ Gd=
+ 1.82370500e-11

.Model Wmodel_Trace2124::MIPI_DSI0_DATA2_N W MODELTYPE=RLGC N=1
+ Lo=
+ 3.58484574e-07
+ Co=
+ 9.37055974e-11
+ Ro=
+ 4.84133902e+00
+ Go=
+ 0.00000000e+00
+ Rs=
+ 1.72420198e-03
+ Gd=
+ 1.82370500e-11

.Model Wmodel_Trace2124_Auto_1033::MIPI_DSI0_DATA2_N W MODELTYPE=RLGC N=2
+ Lo=
+ 3.57958129e-07
+ 3.23821050e-08 3.57958129e-07
+ Co=
+ 9.38066827e-11
+ -2.44849242e-12 9.38066827e-11
+ Ro=
+ 4.84133902e+00
+ 0.00000000e+00 4.84133902e+00
+ Go=
+ 0.00000000e+00
+ -0.00000000e+00 0.00000000e+00
+ Rs=
+ 1.72420198e-03
+ -0.00000000e+00 1.72420198e-03
+ Gd=
+ 1.82243359e-11
+ -1.55517670e-14 1.82243359e-11

.Model Wmodel_Trace2125::MIPI_DSI0_DATA2_N W MODELTYPE=RLGC N=1
+ Lo=
+ 3.58484574e-07
+ Co=
+ 9.37055974e-11
+ Ro=
+ 4.84133902e+00
+ Go=
+ 0.00000000e+00
+ Rs=
+ 1.72420198e-03
+ Gd=
+ 1.82370500e-11

.Model Wmodel_Trace2126::MIPI_DSI0_DATA2_N W MODELTYPE=RLGC N=1
+ Lo=
+ 3.58484574e-07
+ Co=
+ 9.37055974e-11
+ Ro=
+ 4.84133902e+00
+ Go=
+ 0.00000000e+00
+ Rs=
+ 1.72420198e-03
+ Gd=
+ 1.82370500e-11

.Model Wmodel_Trace2126_Auto_1019::MIPI_DSI0_DATA2_N W MODELTYPE=RLGC N=2
+ Lo=
+ 3.57565426e-07
+ 4.12661036e-08 3.57565426e-07
+ Co=
+ 9.39127255e-11
+ -3.55167549e-12 9.39127255e-11
+ Ro=
+ 4.84133902e+00
+ 0.00000000e+00 4.84133902e+00
+ Go=
+ 0.00000000e+00
+ -0.00000000e+00 0.00000000e+00
+ Rs=
+ 1.72420198e-03
+ -0.00000000e+00 1.72420198e-03
+ Gd=
+ 1.82178172e-11
+ -1.02526579e-13 1.82178172e-11

.Model Wmodel_Trace2127_Auto_201::MIPI_DSI0_DATA2_N W MODELTYPE=RLGC N=1
+ Lo=
+ 3.32029740e-07
+ Co=
+ 1.03489020e-10
+ Ro=
+ 3.96831067e+00
+ Go=
+ 0.00000000e+00
+ Rs=
+ 1.55902417e-03
+ Gd=
+ 2.04067990e-11

.Model Wmodel_Trace2129::MIPI_DSI0_DATA2_N W MODELTYPE=RLGC N=1
+ Lo=
+ 3.32029740e-07
+ Co=
+ 1.03489020e-10
+ Ro=
+ 3.96831067e+00
+ Go=
+ 0.00000000e+00
+ Rs=
+ 1.55902417e-03
+ Gd=
+ 2.04067990e-11

.Model Wmodel_Trace2130::MIPI_DSI0_DATA2_N W MODELTYPE=RLGC N=2
+ Lo=
+ 3.31013857e-07
+ 3.82221558e-08 3.31013857e-07
+ Co=
+ 1.03725077e-10
+ -3.87536926e-12 1.03725077e-10
+ Ro=
+ 3.96831067e+00
+ 0.00000000e+00 3.96831067e+00
+ Go=
+ 0.00000000e+00
+ -0.00000000e+00 0.00000000e+00
+ Rs=
+ 1.55902417e-03
+ -0.00000000e+00 1.55902417e-03
+ Gd=
+ 2.03854798e-11
+ -1.13257428e-13 2.03854798e-11

.Model Wmodel_Trace2132_Auto_283::MIPI_DSI0_DATA2_N W MODELTYPE=RLGC N=1
+ Lo=
+ 3.32029740e-07
+ Co=
+ 1.03489020e-10
+ Ro=
+ 3.96831067e+00
+ Go=
+ 0.00000000e+00
+ Rs=
+ 1.55902417e-03
+ Gd=
+ 2.04067990e-11

.Model Wmodel_Trace2133::MIPI_DSI0_DATA2_N W MODELTYPE=RLGC N=1
+ Lo=
+ 3.32029740e-07
+ Co=
+ 1.03489020e-10
+ Ro=
+ 3.96831067e+00
+ Go=
+ 0.00000000e+00
+ Rs=
+ 1.55902417e-03
+ Gd=
+ 2.04067990e-11

.Model Wmodel_Trace2133_Auto_61::MIPI_DSI0_DATA2_N W MODELTYPE=RLGC N=2
+ Lo=
+ 3.30748904e-07
+ 4.21593990e-08 3.30748904e-07
+ Co=
+ 1.03807716e-10
+ -4.52055469e-12 1.03807716e-10
+ Ro=
+ 3.96831067e+00
+ 0.00000000e+00 3.96831067e+00
+ Go=
+ 0.00000000e+00
+ -0.00000000e+00 0.00000000e+00
+ Rs=
+ 1.55902417e-03
+ -0.00000000e+00 1.55902417e-03
+ Gd=
+ 2.03827260e-11
+ -1.75097034e-13 2.03827260e-11

.Model Wmodel_Trace2133_Auto_62::MIPI_DSI0_DATA2_N W MODELTYPE=RLGC N=1
+ Lo=
+ 3.32029740e-07
+ Co=
+ 1.03489020e-10
+ Ro=
+ 3.96831067e+00
+ Go=
+ 0.00000000e+00
+ Rs=
+ 1.55902417e-03
+ Gd=
+ 2.04067990e-11

.Model Wmodel_Trace2135::MIPI_DSI0_DATA2_N W MODELTYPE=RLGC N=1
+ Lo=
+ 3.32029740e-07
+ Co=
+ 1.03489020e-10
+ Ro=
+ 3.96831067e+00
+ Go=
+ 0.00000000e+00
+ Rs=
+ 1.55902417e-03
+ Gd=
+ 2.04067990e-11

.Model Wmodel_Trace2136::MIPI_DSI0_DATA2_N W MODELTYPE=RLGC N=2
+ Lo=
+ 3.30748548e-07
+ 4.21643423e-08 3.30748548e-07
+ Co=
+ 1.03807831e-10
+ -4.52139172e-12 1.03807831e-10
+ Ro=
+ 3.96831067e+00
+ 0.00000000e+00 3.96831067e+00
+ Go=
+ 0.00000000e+00
+ -0.00000000e+00 0.00000000e+00
+ Rs=
+ 1.55902417e-03
+ -0.00000000e+00 1.55902417e-03
+ Gd=
+ 2.03827231e-11
+ -1.75181003e-13 2.03827231e-11

.Model Wmodel_Trace2136_Auto_72::MIPI_DSI0_DATA2_N W MODELTYPE=RLGC N=1
+ Lo=
+ 3.32029740e-07
+ Co=
+ 1.03489020e-10
+ Ro=
+ 3.96831067e+00
+ Go=
+ 0.00000000e+00
+ Rs=
+ 1.55902417e-03
+ Gd=
+ 2.04067990e-11

.Model Wmodel_Trace2139::MIPI_DSI0_DATA2_N W MODELTYPE=RLGC N=1
+ Lo=
+ 3.32029740e-07
+ Co=
+ 1.03489020e-10
+ Ro=
+ 3.96831067e+00
+ Go=
+ 0.00000000e+00
+ Rs=
+ 1.55902417e-03
+ Gd=
+ 2.04067990e-11

.Model Wmodel_Trace2145::MIPI_DSI0_DATA1_N W MODELTYPE=RLGC N=1
+ Lo=
+ 3.32029740e-07
+ Co=
+ 1.03489020e-10
+ Ro=
+ 3.96831067e+00
+ Go=
+ 0.00000000e+00
+ Rs=
+ 1.55902417e-03
+ Gd=
+ 2.04067990e-11

.Model Wmodel_Trace2145_Auto_1545::MIPI_DSI0_DATA1_N W MODELTYPE=RLGC N=4
+ Lo=
+ 3.30431667e-07
+ 4.48365008e-08 3.29201723e-07
+ 1.23520383e-08 4.16328766e-08 3.29831427e-07
+ 4.99149568e-09 1.06404848e-08 3.51474775e-08 3.31111953e-07
+ Co=
+ 1.03889781e-10
+ -5.00052455e-12 1.04200325e-10
+ -5.44949974e-13 -4.45253238e-12 1.03997048e-10
+ -2.24753271e-13 -4.84667822e-13 -3.40730473e-12 1.03682117e-10
+ Ro=
+ 3.96831067e+00
+ 0.00000000e+00 3.96831067e+00
+ 0.00000000e+00 0.00000000e+00 3.96831067e+00
+ 0.00000000e+00 0.00000000e+00 0.00000000e+00 3.96831067e+00
+ Go=
+ 0.00000000e+00
+ -0.00000000e+00 0.00000000e+00
+ -0.00000000e+00 -0.00000000e+00 0.00000000e+00
+ -0.00000000e+00 -0.00000000e+00 -0.00000000e+00 0.00000000e+00
+ Rs=
+ 1.55902417e-03
+ -0.00000000e+00 1.55902417e-03
+ -0.00000000e+00 -0.00000000e+00 1.55902417e-03
+ -0.00000000e+00 -0.00000000e+00 -0.00000000e+00 1.55902417e-03
+ Gd=
+ 2.03803667e-11
+ -2.33632413e-13 2.03578060e-11
+ -0.00000000e+00 -1.83154599e-13 2.03638762e-11
+ -0.00000000e+00 -0.00000000e+00 -8.00083604e-14 2.03870524e-11

.Model Wmodel_Trace2145_Auto_1546::MIPI_DSI0_DATA1_N W MODELTYPE=RLGC N=1
+ Lo=
+ 3.32029740e-07
+ Co=
+ 1.03489020e-10
+ Ro=
+ 3.96831067e+00
+ Go=
+ 0.00000000e+00
+ Rs=
+ 1.55902417e-03
+ Gd=
+ 2.04067990e-11

.Model Wmodel_Trace2145_Auto_1553::MIPI_DSI0_DATA1_N W MODELTYPE=RLGC N=5
+ Lo=
+ 3.30427471e-07
+ 4.48281282e-08 3.29183964e-07
+ 1.23260130e-08 4.15705697e-08 3.29564968e-07
+ 5.14332692e-09 1.11807273e-08 3.84257050e-08 3.29879218e-07
+ 2.79693040e-09 4.81556376e-09 1.06524920e-08 3.80773205e-08 3.30935363e-07
+ Co=
+ 1.03890115e-10
+ -4.99990485e-12 1.04201514e-10
+ -5.41805241e-13 -4.44557542e-12 1.04062879e-10
+ -2.23185896e-13 -4.93626063e-13 -3.92365259e-12 1.03979124e-10
+ -1.26062133e-13 -2.10607606e-13 -4.86685335e-13 -3.86052455e-12 1.03732992e-10
+ Ro=
+ 3.96831067e+00
+ 0.00000000e+00 3.96831067e+00
+ 0.00000000e+00 0.00000000e+00 3.96831067e+00
+ 0.00000000e+00 0.00000000e+00 0.00000000e+00 3.96831067e+00
+ 0.00000000e+00 0.00000000e+00 0.00000000e+00 0.00000000e+00 3.96831067e+00
+ Go=
+ 0.00000000e+00
+ -0.00000000e+00 0.00000000e+00
+ -0.00000000e+00 -0.00000000e+00 0.00000000e+00
+ -0.00000000e+00 -0.00000000e+00 -0.00000000e+00 0.00000000e+00
+ -0.00000000e+00 -0.00000000e+00 -0.00000000e+00 -0.00000000e+00 0.00000000e+00
+ Rs=
+ 1.55902417e-03
+ -0.00000000e+00 1.55902417e-03
+ -0.00000000e+00 -0.00000000e+00 1.55902417e-03
+ -0.00000000e+00 -0.00000000e+00 -0.00000000e+00 1.55902417e-03
+ -0.00000000e+00 -0.00000000e+00 -0.00000000e+00 -0.00000000e+00 1.55902417e-03
+ Gd=
+ 2.03803224e-11
+ -2.33710793e-13 2.03576628e-11
+ -0.00000000e+00 -1.83836072e-13 2.03605800e-11
+ -0.00000000e+00 -0.00000000e+00 -1.32004957e-13 2.03636180e-11
+ -0.00000000e+00 -0.00000000e+00 -0.00000000e+00 -1.19110807e-13 2.03846043e-11

.Model Wmodel_Trace2145_Auto_1566::MIPI_DSI0_DATA1_N W MODELTYPE=RLGC N=5
+ Lo=
+ 3.30427282e-07
+ 4.48277318e-08 3.29183135e-07
+ 1.23248422e-08 4.15681113e-08 3.29557565e-07
+ 5.13712525e-09 1.11673404e-08 3.83836853e-08 3.29623734e-07
+ 2.87581698e-09 4.99942158e-09 1.12645031e-08 4.18836360e-08 3.30668901e-07
+ Co=
+ 1.03890125e-10
+ -4.99988435e-12 1.04201555e-10
+ -5.41738250e-13 -4.44544724e-12 1.04063255e-10
+ -2.22003710e-13 -4.91499624e-13 -3.91796280e-12 1.04058855e-10
+ -1.28038747e-13 -2.15619446e-13 -5.06833323e-13 -4.48641426e-12 1.03813934e-10
+ Ro=
+ 3.96831067e+00
+ 0.00000000e+00 3.96831067e+00
+ 0.00000000e+00 0.00000000e+00 3.96831067e+00
+ 0.00000000e+00 0.00000000e+00 0.00000000e+00 3.96831067e+00
+ 0.00000000e+00 0.00000000e+00 0.00000000e+00 0.00000000e+00 3.96831067e+00
+ Go=
+ 0.00000000e+00
+ -0.00000000e+00 0.00000000e+00
+ -0.00000000e+00 -0.00000000e+00 0.00000000e+00
+ -0.00000000e+00 -0.00000000e+00 -0.00000000e+00 0.00000000e+00
+ -0.00000000e+00 -0.00000000e+00 -0.00000000e+00 -0.00000000e+00 0.00000000e+00
+ Rs=
+ 1.55902417e-03
+ -0.00000000e+00 1.55902417e-03
+ -0.00000000e+00 -0.00000000e+00 1.55902417e-03
+ -0.00000000e+00 -0.00000000e+00 -0.00000000e+00 1.55902417e-03
+ -0.00000000e+00 -0.00000000e+00 -0.00000000e+00 -0.00000000e+00 1.55902417e-03
+ Gd=
+ 2.03803216e-11
+ -2.33712444e-13 2.03576594e-11
+ -0.00000000e+00 -1.83847713e-13 2.03605438e-11
+ -0.00000000e+00 -0.00000000e+00 -1.32462409e-13 2.03610947e-11
+ -0.00000000e+00 -0.00000000e+00 -0.00000000e+00 -1.79438148e-13 2.03818926e-11

.Model Wmodel_Trace2145_Auto_1578::MIPI_DSI0_DATA1_N W MODELTYPE=RLGC N=5
+ Lo=
+ 3.30427282e-07
+ 4.48277318e-08 3.29183135e-07
+ 1.23248422e-08 4.15681113e-08 3.29557565e-07
+ 5.13712525e-09 1.11673404e-08 3.83836853e-08 3.29623734e-07
+ 2.87581698e-09 4.99942158e-09 1.12645031e-08 4.18836360e-08 3.30668901e-07
+ Co=
+ 1.03890125e-10
+ -4.99988435e-12 1.04201555e-10
+ -5.41738250e-13 -4.44544724e-12 1.04063255e-10
+ -2.22003710e-13 -4.91499624e-13 -3.91796280e-12 1.04058855e-10
+ -1.28038747e-13 -2.15619446e-13 -5.06833323e-13 -4.48641426e-12 1.03813934e-10
+ Ro=
+ 3.96831067e+00
+ 0.00000000e+00 3.96831067e+00
+ 0.00000000e+00 0.00000000e+00 3.96831067e+00
+ 0.00000000e+00 0.00000000e+00 0.00000000e+00 3.96831067e+00
+ 0.00000000e+00 0.00000000e+00 0.00000000e+00 0.00000000e+00 3.96831067e+00
+ Go=
+ 0.00000000e+00
+ -0.00000000e+00 0.00000000e+00
+ -0.00000000e+00 -0.00000000e+00 0.00000000e+00
+ -0.00000000e+00 -0.00000000e+00 -0.00000000e+00 0.00000000e+00
+ -0.00000000e+00 -0.00000000e+00 -0.00000000e+00 -0.00000000e+00 0.00000000e+00
+ Rs=
+ 1.55902417e-03
+ -0.00000000e+00 1.55902417e-03
+ -0.00000000e+00 -0.00000000e+00 1.55902417e-03
+ -0.00000000e+00 -0.00000000e+00 -0.00000000e+00 1.55902417e-03
+ -0.00000000e+00 -0.00000000e+00 -0.00000000e+00 -0.00000000e+00 1.55902417e-03
+ Gd=
+ 2.03803216e-11
+ -2.33712444e-13 2.03576594e-11
+ -0.00000000e+00 -1.83847713e-13 2.03605438e-11
+ -0.00000000e+00 -0.00000000e+00 -1.32462409e-13 2.03610947e-11
+ -0.00000000e+00 -0.00000000e+00 -0.00000000e+00 -1.79438148e-13 2.03818926e-11

.Model Wmodel_Trace2145_Auto_1587::MIPI_DSI0_DATA1_N W MODELTYPE=RLGC N=1
+ Lo=
+ 3.32029740e-07
+ Co=
+ 1.03489020e-10
+ Ro=
+ 3.96831067e+00
+ Go=
+ 0.00000000e+00
+ Rs=
+ 1.55902417e-03
+ Gd=
+ 2.04067990e-11

.Model Wmodel_Trace2145_Auto_1592::MIPI_DSI0_DATA1_N W MODELTYPE=RLGC N=1
+ Lo=
+ 3.32029740e-07
+ Co=
+ 1.03489020e-10
+ Ro=
+ 3.96831067e+00
+ Go=
+ 0.00000000e+00
+ Rs=
+ 1.55902417e-03
+ Gd=
+ 2.04067990e-11

.Model Wmodel_Trace2146::MIPI_DSI0_DATA1_N W MODELTYPE=RLGC N=1
+ Lo=
+ 3.32029740e-07
+ Co=
+ 1.03489020e-10
+ Ro=
+ 3.96831067e+00
+ Go=
+ 0.00000000e+00
+ Rs=
+ 1.55902417e-03
+ Gd=
+ 2.04067990e-11

.Model Wmodel_Trace2146_Auto_1384::MIPI_DSI0_DATA1_N W MODELTYPE=RLGC N=1
+ Lo=
+ 3.32029740e-07
+ Co=
+ 1.03489020e-10
+ Ro=
+ 3.96831067e+00
+ Go=
+ 0.00000000e+00
+ Rs=
+ 1.55902417e-03
+ Gd=
+ 2.04067990e-11

.Model Wmodel_Trace2147::MIPI_DSI0_DATA1_N W MODELTYPE=RLGC N=1
+ Lo=
+ 3.32029740e-07
+ Co=
+ 1.03489020e-10
+ Ro=
+ 3.96831067e+00
+ Go=
+ 0.00000000e+00
+ Rs=
+ 1.55902417e-03
+ Gd=
+ 2.04067990e-11

.Model Wmodel_Trace2147_Auto_1386::MIPI_DSI0_DATA1_N W MODELTYPE=RLGC N=1
+ Lo=
+ 3.32029740e-07
+ Co=
+ 1.03489020e-10
+ Ro=
+ 3.96831067e+00
+ Go=
+ 0.00000000e+00
+ Rs=
+ 1.55902417e-03
+ Gd=
+ 2.04067990e-11

.Model Wmodel_Trace2148::MIPI_DSI0_DATA1_N W MODELTYPE=RLGC N=1
+ Lo=
+ 3.32029740e-07
+ Co=
+ 1.03489020e-10
+ Ro=
+ 3.96831067e+00
+ Go=
+ 0.00000000e+00
+ Rs=
+ 1.55902417e-03
+ Gd=
+ 2.04067990e-11

.Model Wmodel_Trace2151_Auto_1388::MIPI_DSI0_DATA1_N W MODELTYPE=RLGC N=1
+ Lo=
+ 3.32029740e-07
+ Co=
+ 1.03489020e-10
+ Ro=
+ 3.96831067e+00
+ Go=
+ 0.00000000e+00
+ Rs=
+ 1.55902417e-03
+ Gd=
+ 2.04067990e-11

.Model Wmodel_Trace2152::MIPI_DSI0_DATA1_N W MODELTYPE=RLGC N=1
+ Lo=
+ 3.32029740e-07
+ Co=
+ 1.03489020e-10
+ Ro=
+ 3.96831067e+00
+ Go=
+ 0.00000000e+00
+ Rs=
+ 1.55902417e-03
+ Gd=
+ 2.04067990e-11

.Model Wmodel_Trace2155_Auto_1396::MIPI_DSI0_DATA1_N W MODELTYPE=RLGC N=1
+ Lo=
+ 3.32029740e-07
+ Co=
+ 1.03489020e-10
+ Ro=
+ 3.96831067e+00
+ Go=
+ 0.00000000e+00
+ Rs=
+ 1.55902417e-03
+ Gd=
+ 2.04067990e-11

.Model Wmodel_Trace2157::MIPI_DSI0_DATA1_N W MODELTYPE=RLGC N=1
+ Lo=
+ 3.32029740e-07
+ Co=
+ 1.03489020e-10
+ Ro=
+ 3.96831067e+00
+ Go=
+ 0.00000000e+00
+ Rs=
+ 1.55902417e-03
+ Gd=
+ 2.04067990e-11

.Model Wmodel_Trace2157_Auto_1402::MIPI_DSI0_DATA1_N W MODELTYPE=RLGC N=1
+ Lo=
+ 3.32029740e-07
+ Co=
+ 1.03489020e-10
+ Ro=
+ 3.96831067e+00
+ Go=
+ 0.00000000e+00
+ Rs=
+ 1.55902417e-03
+ Gd=
+ 2.04067990e-11

.Model Wmodel_Trace2159#BP0::MIPI_DSI0_DATA1_N W MODELTYPE=RLGC N=1
+ Lo=
+ 3.32029740e-07
+ Co=
+ 1.03489020e-10
+ Ro=
+ 3.96831067e+00
+ Go=
+ 0.00000000e+00
+ Rs=
+ 1.55902417e-03
+ Gd=
+ 2.04067990e-11

.Model Wmodel_Trace2161#BP0::MIPI_DSI0_DATA1_N W MODELTYPE=RLGC N=1
+ Lo=
+ 3.32029740e-07
+ Co=
+ 1.03489020e-10
+ Ro=
+ 3.96831067e+00
+ Go=
+ 0.00000000e+00
+ Rs=
+ 1.55902417e-03
+ Gd=
+ 2.04067990e-11

.Model Wmodel_Trace2163::MIPI_DSI0_DATA1_N W MODELTYPE=RLGC N=1
+ Lo=
+ 3.32029740e-07
+ Co=
+ 1.03489020e-10
+ Ro=
+ 3.96831067e+00
+ Go=
+ 0.00000000e+00
+ Rs=
+ 1.55902417e-03
+ Gd=
+ 2.04067990e-11

.Model Wmodel_Trace2165::MIPI_DSI0_DATA1_N W MODELTYPE=RLGC N=1
+ Lo=
+ 3.32029740e-07
+ Co=
+ 1.03489020e-10
+ Ro=
+ 3.96831067e+00
+ Go=
+ 0.00000000e+00
+ Rs=
+ 1.55902417e-03
+ Gd=
+ 2.04067990e-11

.Model Wmodel_Trace2167::MIPI_DSI0_DATA1_N W MODELTYPE=RLGC N=1
+ Lo=
+ 3.32029740e-07
+ Co=
+ 1.03489020e-10
+ Ro=
+ 3.96831067e+00
+ Go=
+ 0.00000000e+00
+ Rs=
+ 1.55902417e-03
+ Gd=
+ 2.04067990e-11

.Model Wmodel_Trace2173::MIPI_DSI0_DATA1_N W MODELTYPE=RLGC N=1
+ Lo=
+ 3.32029740e-07
+ Co=
+ 1.03489020e-10
+ Ro=
+ 3.96831067e+00
+ Go=
+ 0.00000000e+00
+ Rs=
+ 1.55902417e-03
+ Gd=
+ 2.04067990e-11

.Model Wmodel_Trace2183#BP0::MIPI_DSI0_DATA1_N W MODELTYPE=RLGC N=1
+ Lo=
+ 3.32029740e-07
+ Co=
+ 1.03489020e-10
+ Ro=
+ 3.96831067e+00
+ Go=
+ 0.00000000e+00
+ Rs=
+ 1.55902417e-03
+ Gd=
+ 2.04067990e-11

.Model Wmodel_Trace2183::MIPI_DSI0_DATA1_N W MODELTYPE=RLGC N=1
+ Lo=
+ 3.32029740e-07
+ Co=
+ 1.03489020e-10
+ Ro=
+ 3.96831067e+00
+ Go=
+ 0.00000000e+00
+ Rs=
+ 1.55902417e-03
+ Gd=
+ 2.04067990e-11

.Model Wmodel_Trace2185::MIPI_DSI0_DATA1_N W MODELTYPE=RLGC N=1
+ Lo=
+ 3.32029740e-07
+ Co=
+ 1.03489020e-10
+ Ro=
+ 3.96831067e+00
+ Go=
+ 0.00000000e+00
+ Rs=
+ 1.55902417e-03
+ Gd=
+ 2.04067990e-11

.Model Wmodel_Trace2191::MIPI_DSI0_DATA1_N W MODELTYPE=RLGC N=1
+ Lo=
+ 3.32029740e-07
+ Co=
+ 1.03489020e-10
+ Ro=
+ 3.96831067e+00
+ Go=
+ 0.00000000e+00
+ Rs=
+ 1.55902417e-03
+ Gd=
+ 2.04067990e-11

.Model Wmodel_Trace2193::MIPI_DSI0_DATA1_N W MODELTYPE=RLGC N=1
+ Lo=
+ 3.32029740e-07
+ Co=
+ 1.03489020e-10
+ Ro=
+ 3.96831067e+00
+ Go=
+ 0.00000000e+00
+ Rs=
+ 1.55902417e-03
+ Gd=
+ 2.04067990e-11

.Model Wmodel_Trace2193_Auto_101::MIPI_DSI0_DATA1_N W MODELTYPE=RLGC N=1
+ Lo=
+ 3.32029740e-07
+ Co=
+ 1.03489020e-10
+ Ro=
+ 3.96831067e+00
+ Go=
+ 0.00000000e+00
+ Rs=
+ 1.55902417e-03
+ Gd=
+ 2.04067990e-11

.Model Wmodel_Trace2195::MIPI_DSI0_DATA1_N W MODELTYPE=RLGC N=1
+ Lo=
+ 3.32029740e-07
+ Co=
+ 1.03489020e-10
+ Ro=
+ 3.96831067e+00
+ Go=
+ 0.00000000e+00
+ Rs=
+ 1.55902417e-03
+ Gd=
+ 2.04067990e-11

.Model Wmodel_Trace2200::MIPI_DSI0_DATA1_N W MODELTYPE=RLGC N=3
+ Lo=
+ 3.30867537e-07
+ 3.91991107e-08 3.29664831e-07
+ 1.14762013e-08 4.19224099e-08 3.30681504e-07
+ Co=
+ 1.03754385e-10
+ -4.03902082e-12 1.04063840e-10
+ -5.26461422e-13 -4.49024014e-12 1.03813079e-10
+ Ro=
+ 3.96831067e+00
+ 0.00000000e+00 3.96831067e+00
+ 0.00000000e+00 0.00000000e+00 3.96831067e+00
+ Go=
+ 0.00000000e+00
+ -0.00000000e+00 0.00000000e+00
+ -0.00000000e+00 -0.00000000e+00 0.00000000e+00
+ Rs=
+ 1.55902417e-03
+ -0.00000000e+00 1.55902417e-03
+ -0.00000000e+00 -0.00000000e+00 1.55902417e-03
+ Gd=
+ 2.03838570e-11
+ -1.36043220e-13 2.03614331e-11
+ -0.00000000e+00 -1.79376645e-13 2.03820429e-11

.Model Wmodel_Trace2201::MIPI_DSI0_DATA1_N W MODELTYPE=RLGC N=3
+ Lo=
+ 3.30411138e-07
+ 4.52416132e-08 3.29226877e-07
+ 1.25013522e-08 4.18446720e-08 3.30667793e-07
+ Co=
+ 1.03899393e-10
+ -5.07039061e-12 1.04206749e-10
+ -5.58828000e-13 -4.47977987e-12 1.03813691e-10
+ Ro=
+ 3.96831067e+00
+ 0.00000000e+00 3.96831067e+00
+ 0.00000000e+00 0.00000000e+00 3.96831067e+00
+ Go=
+ 0.00000000e+00
+ -0.00000000e+00 0.00000000e+00
+ -0.00000000e+00 -0.00000000e+00 0.00000000e+00
+ Rs=
+ 1.55902417e-03
+ -0.00000000e+00 1.55902417e-03
+ -0.00000000e+00 -0.00000000e+00 1.55902417e-03
+ Gd=
+ 2.03803438e-11
+ -2.40647546e-13 2.03582288e-11
+ -0.00000000e+00 -1.80119086e-13 2.03819810e-11

.Model Wmodel_Trace2202::MIPI_DSI0_DATA1_N W MODELTYPE=RLGC N=3
+ Lo=
+ 3.30841744e-07
+ 3.95751903e-08 3.29640451e-07
+ 1.15414075e-08 4.19135090e-08 3.30680990e-07
+ Co=
+ 1.03762121e-10
+ -4.10025076e-12 1.04071348e-10
+ -5.28623477e-13 -4.48888551e-12 1.03813017e-10
+ Ro=
+ 3.96831067e+00
+ 0.00000000e+00 3.96831067e+00
+ 0.00000000e+00 0.00000000e+00 3.96831067e+00
+ Go=
+ 0.00000000e+00
+ -0.00000000e+00 0.00000000e+00
+ -0.00000000e+00 -0.00000000e+00 0.00000000e+00
+ Rs=
+ 1.55902417e-03
+ -0.00000000e+00 1.55902417e-03
+ -0.00000000e+00 -0.00000000e+00 1.55902417e-03
+ Gd=
+ 2.03835774e-11
+ -1.41861933e-13 2.03611752e-11
+ -0.00000000e+00 -1.79349871e-13 2.03820413e-11

.Model Wmodel_Trace2204::MIPI_DSI0_DATA1_N W MODELTYPE=RLGC N=1
+ Lo=
+ 3.32029740e-07
+ Co=
+ 1.03489020e-10
+ Ro=
+ 3.96831067e+00
+ Go=
+ 0.00000000e+00
+ Rs=
+ 1.55902417e-03
+ Gd=
+ 2.04067990e-11

.Model Wmodel_Trace2204_Auto_105::MIPI_DSI0_DATA1_N W MODELTYPE=RLGC N=4
+ Lo=
+ 3.30633562e-07
+ 4.29801982e-08 3.30254182e-07
+ 8.78286337e-09 2.50616551e-08 3.30254182e-07
+ 4.30471686e-09 8.78286337e-09 4.29801982e-08 3.30633562e-07
+ Co=
+ 1.03834419e-10
+ -4.66731758e-12 1.03903340e-10
+ -4.14850270e-13 -2.03832657e-12 1.03903340e-10
+ -1.93066753e-13 -4.14850270e-13 -4.66731758e-12 1.03834419e-10
+ Ro=
+ 3.96831067e+00
+ 0.00000000e+00 3.96831067e+00
+ 0.00000000e+00 0.00000000e+00 3.96831067e+00
+ 0.00000000e+00 0.00000000e+00 0.00000000e+00 3.96831067e+00
+ Go=
+ 0.00000000e+00
+ -0.00000000e+00 0.00000000e+00
+ -0.00000000e+00 -0.00000000e+00 0.00000000e+00
+ -0.00000000e+00 -0.00000000e+00 -0.00000000e+00 0.00000000e+00
+ Rs=
+ 1.55902417e-03
+ -0.00000000e+00 1.55902417e-03
+ -0.00000000e+00 -0.00000000e+00 1.55902417e-03
+ -0.00000000e+00 -0.00000000e+00 -0.00000000e+00 1.55902417e-03
+ Gd=
+ 2.03816126e-11
+ -1.93933137e-13 2.03720797e-11
+ -0.00000000e+00 -0.00000000e+00 2.03720797e-11
+ -0.00000000e+00 -0.00000000e+00 -1.93933137e-13 2.03816126e-11

.Model Wmodel_Trace2204_Auto_106::MIPI_DSI0_DATA1_N W MODELTYPE=RLGC N=1
+ Lo=
+ 3.32029740e-07
+ Co=
+ 1.03489020e-10
+ Ro=
+ 3.96831067e+00
+ Go=
+ 0.00000000e+00
+ Rs=
+ 1.55902417e-03
+ Gd=
+ 2.04067990e-11

.Model Wmodel_Trace2208::MIPI_DSI0_DATA1_N W MODELTYPE=RLGC N=1
+ Lo=
+ 3.32029740e-07
+ Co=
+ 1.03489020e-10
+ Ro=
+ 3.96831067e+00
+ Go=
+ 0.00000000e+00
+ Rs=
+ 1.55902417e-03
+ Gd=
+ 2.04067990e-11

.Model Wmodel_Trace2210_Auto_245::MIPI_DSI0_DATA1_N W MODELTYPE=RLGC N=1
+ Lo=
+ 3.32029740e-07
+ Co=
+ 1.03489020e-10
+ Ro=
+ 3.96831067e+00
+ Go=
+ 0.00000000e+00
+ Rs=
+ 1.55902417e-03
+ Gd=
+ 2.04067990e-11

.Model Wmodel_Trace2212::MIPI_DSI0_DATA1_N W MODELTYPE=RLGC N=1
+ Lo=
+ 3.32029740e-07
+ Co=
+ 1.03489020e-10
+ Ro=
+ 3.96831067e+00
+ Go=
+ 0.00000000e+00
+ Rs=
+ 1.55902417e-03
+ Gd=
+ 2.04067990e-11

.Model Wmodel_Trace2212_Auto_208::MIPI_DSI0_DATA1_N W MODELTYPE=RLGC N=3
+ Lo=
+ 3.30509557e-07
+ 4.40498111e-08 3.29345435e-07
+ 1.22417336e-08 4.15130883e-08 3.30696454e-07
+ Co=
+ 1.03866982e-10
+ -4.85886576e-12 1.04166813e-10
+ -5.50902573e-13 -4.42303701e-12 1.03805460e-10
+ Ro=
+ 3.96831067e+00
+ 0.00000000e+00 3.96831067e+00
+ 0.00000000e+00 0.00000000e+00 3.96831067e+00
+ Go=
+ 0.00000000e+00
+ -0.00000000e+00 0.00000000e+00
+ -0.00000000e+00 -0.00000000e+00 0.00000000e+00
+ Rs=
+ 1.55902417e-03
+ -0.00000000e+00 1.55902417e-03
+ -0.00000000e+00 -0.00000000e+00 1.55902417e-03
+ Gd=
+ 2.03808506e-11
+ -2.18046058e-13 2.03588683e-11
+ -0.00000000e+00 -1.74061153e-13 2.03822087e-11

.Model Wmodel_Trace2214_Auto_211::MIPI_DSI0_DATA1_N W MODELTYPE=RLGC N=2
+ Lo=
+ 3.30714848e-07
+ 4.26288028e-08 3.30714848e-07
+ Co=
+ 1.03818785e-10
+ -4.60033445e-12 1.03818785e-10
+ Ro=
+ 3.96831067e+00
+ 0.00000000e+00 3.96831067e+00
+ Go=
+ 0.00000000e+00
+ -0.00000000e+00 0.00000000e+00
+ Rs=
+ 1.55902417e-03
+ -0.00000000e+00 1.55902417e-03
+ Gd=
+ 2.03824521e-11
+ -1.83140082e-13 2.03824521e-11

.Model Wmodel_Trace2214_Auto_212::MIPI_DSI0_DATA1_N W MODELTYPE=RLGC N=1
+ Lo=
+ 3.32029740e-07
+ Co=
+ 1.03489020e-10
+ Ro=
+ 3.96831067e+00
+ Go=
+ 0.00000000e+00
+ Rs=
+ 1.55902417e-03
+ Gd=
+ 2.04067990e-11

.Model Wmodel_Trace2216::MIPI_DSI0_DATA1_N W MODELTYPE=RLGC N=1
+ Lo=
+ 3.32029740e-07
+ Co=
+ 1.03489020e-10
+ Ro=
+ 3.96831067e+00
+ Go=
+ 0.00000000e+00
+ Rs=
+ 1.55902417e-03
+ Gd=
+ 2.04067990e-11

.Model Wmodel_Trace2218_Auto_254::MIPI_DSI0_DATA1_N W MODELTYPE=RLGC N=2
+ Lo=
+ 3.29672162e-07
+ 5.44579627e-08 3.29672162e-07
+ Co=
+ 1.04197749e-10
+ -6.80127384e-12 1.04197749e-10
+ Ro=
+ 3.96831067e+00
+ 0.00000000e+00 3.96831067e+00
+ Go=
+ 0.00000000e+00
+ -0.00000000e+00 0.00000000e+00
+ Rs=
+ 1.55902417e-03
+ -0.00000000e+00 1.55902417e-03
+ Gd=
+ 2.03818301e-11
+ -4.29999838e-13 2.03818301e-11

.Model Wmodel_Trace2220::MIPI_DSI0_DATA1_N W MODELTYPE=RLGC N=1
+ Lo=
+ 3.32029740e-07
+ Co=
+ 1.03489020e-10
+ Ro=
+ 3.96831067e+00
+ Go=
+ 0.00000000e+00
+ Rs=
+ 1.55902417e-03
+ Gd=
+ 2.04067990e-11

.Model Wmodel_Trace2222::MIPI_DSI0_DATA1_N W MODELTYPE=RLGC N=1
+ Lo=
+ 3.58484574e-07
+ Co=
+ 9.37055974e-11
+ Ro=
+ 4.84133902e+00
+ Go=
+ 0.00000000e+00
+ Rs=
+ 1.72420198e-03
+ Gd=
+ 1.82370500e-11

.Model Wmodel_Trace2223::MIPI_DSI0_DATA1_N W MODELTYPE=RLGC N=1
+ Lo=
+ 3.58484574e-07
+ Co=
+ 9.37055974e-11
+ Ro=
+ 4.84133902e+00
+ Go=
+ 0.00000000e+00
+ Rs=
+ 1.72420198e-03
+ Gd=
+ 1.82370500e-11

.Model Wmodel_Trace2223_Auto_1026::MIPI_DSI0_DATA1_N W MODELTYPE=RLGC N=1
+ Lo=
+ 3.58484574e-07
+ Co=
+ 9.37055974e-11
+ Ro=
+ 4.84133902e+00
+ Go=
+ 0.00000000e+00
+ Rs=
+ 1.72420198e-03
+ Gd=
+ 1.82370500e-11

.Model Wmodel_Trace2227::MIPI_DSI0_DATA1_N W MODELTYPE=RLGC N=1
+ Lo=
+ 3.58484574e-07
+ Co=
+ 9.37055974e-11
+ Ro=
+ 4.84133902e+00
+ Go=
+ 0.00000000e+00
+ Rs=
+ 1.72420198e-03
+ Gd=
+ 1.82370500e-11

.Model Wmodel_Trace2233::MIPI_DSI0_DATA0_N W MODELTYPE=RLGC N=1
+ Lo=
+ 3.58484574e-07
+ Co=
+ 9.37055974e-11
+ Ro=
+ 4.84133902e+00
+ Go=
+ 0.00000000e+00
+ Rs=
+ 1.72420198e-03
+ Gd=
+ 1.82370500e-11

.Model Wmodel_Trace2234::MIPI_DSI0_DATA0_N W MODELTYPE=RLGC N=1
+ Lo=
+ 3.58484574e-07
+ Co=
+ 9.37055974e-11
+ Ro=
+ 4.84133902e+00
+ Go=
+ 0.00000000e+00
+ Rs=
+ 1.72420198e-03
+ Gd=
+ 1.82370500e-11

.Model Wmodel_Trace2234_Auto_1029::MIPI_DSI0_DATA0_N W MODELTYPE=RLGC N=6
+ Lo=
+ 3.56668253e-07
+ 5.33467756e-08 3.55450359e-07
+ 1.45716742e-08 4.58217964e-08 3.54649684e-07
+ 7.14336713e-09 1.59939903e-08 6.23166933e-08 3.55338889e-07
+ 3.28979045e-09 5.53019941e-09 1.22158666e-08 3.08280500e-08 3.55455036e-07
+ 2.27009829e-09 3.44778995e-09 6.31434644e-09 1.23083712e-08 6.27012271e-08 3.55933834e-07
+ Co=
+ 9.41775694e-11
+ -5.34354142e-12 9.44726265e-11
+ -5.25456652e-13 -4.20376062e-12 9.47686999e-11
+ -2.39779916e-13 -5.56833306e-13 -6.87048480e-12 9.45669610e-11
+ -1.18465384e-13 -1.96736943e-13 -4.39425182e-13 -2.25520499e-12 9.45605506e-11
+ -8.04250518e-14 -1.17710344e-13 -2.05682430e-13 -4.53032527e-13 -6.91265579e-12 9.44711764e-11
+ Ro=
+ 4.84133902e+00
+ 0.00000000e+00 4.84133902e+00
+ 0.00000000e+00 0.00000000e+00 4.84133902e+00
+ 0.00000000e+00 0.00000000e+00 0.00000000e+00 4.84133902e+00
+ 0.00000000e+00 0.00000000e+00 0.00000000e+00 0.00000000e+00 4.84133902e+00
+ 0.00000000e+00 0.00000000e+00 0.00000000e+00 0.00000000e+00 0.00000000e+00 4.84133902e+00
+ Go=
+ 0.00000000e+00
+ -0.00000000e+00 0.00000000e+00
+ -0.00000000e+00 -0.00000000e+00 0.00000000e+00
+ -0.00000000e+00 -0.00000000e+00 -0.00000000e+00 0.00000000e+00
+ -0.00000000e+00 -0.00000000e+00 -0.00000000e+00 -0.00000000e+00 0.00000000e+00
+ -0.00000000e+00 -0.00000000e+00 -0.00000000e+00 -0.00000000e+00 -0.00000000e+00 0.00000000e+00
+ Rs=
+ 1.72420198e-03
+ -0.00000000e+00 1.72420198e-03
+ -0.00000000e+00 -0.00000000e+00 1.72420198e-03
+ -0.00000000e+00 -0.00000000e+00 -0.00000000e+00 1.72420198e-03
+ -0.00000000e+00 -0.00000000e+00 -0.00000000e+00 -0.00000000e+00 1.72420198e-03
+ -0.00000000e+00 -0.00000000e+00 -0.00000000e+00 -0.00000000e+00 -0.00000000e+00 1.72420198e-03
+ Gd=
+ 1.82116149e-11
+ -2.96243956e-13 1.81906346e-11
+ -0.00000000e+00 -1.87021994e-13 1.81937241e-11
+ -0.00000000e+00 -0.00000000e+00 -4.83192136e-13 1.82030969e-11
+ -0.00000000e+00 -0.00000000e+00 -0.00000000e+00 -2.01722238e-14 1.82039049e-11
+ -0.00000000e+00 -0.00000000e+00 -0.00000000e+00 -0.00000000e+00 -4.78486839e-13 1.82149959e-11

.Model Wmodel_Trace2234_Auto_1030::MIPI_DSI0_DATA0_N W MODELTYPE=RLGC N=1
+ Lo=
+ 3.58484574e-07
+ Co=
+ 9.37055974e-11
+ Ro=
+ 4.84133902e+00
+ Go=
+ 0.00000000e+00
+ Rs=
+ 1.72420198e-03
+ Gd=
+ 1.82370500e-11

.Model Wmodel_Trace2234_Auto_1031::MIPI_DSI0_DATA0_N W MODELTYPE=RLGC N=3
+ Lo=
+ 3.56693331e-07
+ 5.34016078e-08 3.55576977e-07
+ 1.47760249e-08 4.63430977e-08 3.57167040e-07
+ Co=
+ 9.41759575e-11
+ -5.34694377e-12 9.44652586e-11
+ -5.52700928e-13 -4.26712012e-12 9.40134403e-11
+ Ro=
+ 4.84133902e+00
+ 0.00000000e+00 4.84133902e+00
+ 0.00000000e+00 0.00000000e+00 4.84133902e+00
+ Go=
+ 0.00000000e+00
+ -0.00000000e+00 0.00000000e+00
+ -0.00000000e+00 -0.00000000e+00 0.00000000e+00
+ Rs=
+ 1.72420198e-03
+ -0.00000000e+00 1.72420198e-03
+ -0.00000000e+00 -0.00000000e+00 1.72420198e-03
+ Gd=
+ 1.82118294e-11
+ -2.95809188e-13 1.81915388e-11
+ -0.00000000e+00 -1.81044300e-13 1.82138422e-11

.Model Wmodel_Trace2235::MIPI_DSI0_DATA0_N W MODELTYPE=RLGC N=1
+ Lo=
+ 3.58484574e-07
+ Co=
+ 9.37055974e-11
+ Ro=
+ 4.84133902e+00
+ Go=
+ 0.00000000e+00
+ Rs=
+ 1.72420198e-03
+ Gd=
+ 1.82370500e-11

.Model Wmodel_Trace2236::MIPI_DSI0_DATA0_N W MODELTYPE=RLGC N=2
+ Lo=
+ 3.57266790e-07
+ 4.65837360e-08 3.57266790e-07
+ Co=
+ 9.40049686e-11
+ -4.29576828e-12 9.40049686e-11
+ Ro=
+ 4.84133902e+00
+ 0.00000000e+00 4.84133902e+00
+ Go=
+ 0.00000000e+00
+ -0.00000000e+00 0.00000000e+00
+ Rs=
+ 1.72420198e-03
+ -0.00000000e+00 1.72420198e-03
+ Gd=
+ 1.82146888e-11
+ -1.74038681e-13 1.82146888e-11

.Model Wmodel_Trace2236_Auto_1016::MIPI_DSI0_DATA0_N W MODELTYPE=RLGC N=1
+ Lo=
+ 3.58484574e-07
+ Co=
+ 9.37055974e-11
+ Ro=
+ 4.84133902e+00
+ Go=
+ 0.00000000e+00
+ Rs=
+ 1.72420198e-03
+ Gd=
+ 1.82370500e-11

.Model Wmodel_Trace2251::MIPI_DSI0_DATA0_N W MODELTYPE=RLGC N=1
+ Lo=
+ 3.32029740e-07
+ Co=
+ 1.03489020e-10
+ Ro=
+ 3.96831067e+00
+ Go=
+ 0.00000000e+00
+ Rs=
+ 1.55902417e-03
+ Gd=
+ 2.04067990e-11

.Model Wmodel_Trace2253_Auto_213::MIPI_DSI0_DATA0_N W MODELTYPE=RLGC N=1
+ Lo=
+ 3.32029740e-07
+ Co=
+ 1.03489020e-10
+ Ro=
+ 3.96831067e+00
+ Go=
+ 0.00000000e+00
+ Rs=
+ 1.55902417e-03
+ Gd=
+ 2.04067990e-11

.Model Wmodel_Trace2253_Auto_217::MIPI_DSI0_DATA0_N W MODELTYPE=RLGC N=4
+ Lo=
+ 3.31077966e-07
+ 3.52107647e-08 3.28809188e-07
+ 1.22475379e-08 5.30929942e-08 3.28410528e-07
+ 5.33121893e-09 1.37092264e-08 4.18011859e-08 3.30627909e-07
+ Co=
+ 1.03686509e-10
+ -3.41901819e-12 1.04357422e-10
+ -5.32684788e-13 -6.57527276e-12 1.04484585e-10
+ -2.40683068e-13 -5.82174883e-13 -4.47994983e-12 1.03817946e-10
+ Ro=
+ 3.96831067e+00
+ 0.00000000e+00 3.96831067e+00
+ 0.00000000e+00 0.00000000e+00 3.96831067e+00
+ 0.00000000e+00 0.00000000e+00 0.00000000e+00 3.96831067e+00
+ Go=
+ 0.00000000e+00
+ -0.00000000e+00 0.00000000e+00
+ -0.00000000e+00 -0.00000000e+00 0.00000000e+00
+ -0.00000000e+00 -0.00000000e+00 -0.00000000e+00 0.00000000e+00
+ Rs=
+ 1.55902417e-03
+ -0.00000000e+00 1.55902417e-03
+ -0.00000000e+00 -0.00000000e+00 1.55902417e-03
+ -0.00000000e+00 -0.00000000e+00 -0.00000000e+00 1.55902417e-03
+ Gd=
+ 2.03867699e-11
+ -8.39691472e-14 2.03626518e-11
+ -0.00000000e+00 -4.19435199e-13 2.03581585e-11
+ -0.00000000e+00 -0.00000000e+00 -1.83161373e-13 2.03817092e-11

.Model Wmodel_Trace2255_Auto_207::MIPI_DSI0_DATA0_N W MODELTYPE=RLGC N=1
+ Lo=
+ 3.32029740e-07
+ Co=
+ 1.03489020e-10
+ Ro=
+ 3.96831067e+00
+ Go=
+ 0.00000000e+00
+ Rs=
+ 1.55902417e-03
+ Gd=
+ 2.04067990e-11

.Model Wmodel_Trace2256::MIPI_DSI0_DATA0_N W MODELTYPE=RLGC N=1
+ Lo=
+ 3.32029740e-07
+ Co=
+ 1.03489020e-10
+ Ro=
+ 3.96831067e+00
+ Go=
+ 0.00000000e+00
+ Rs=
+ 1.55902417e-03
+ Gd=
+ 2.04067990e-11

.Model Wmodel_Trace2257_Auto_87::MIPI_DSI0_DATA0_N W MODELTYPE=RLGC N=1
+ Lo=
+ 3.32029740e-07
+ Co=
+ 1.03489020e-10
+ Ro=
+ 3.96831067e+00
+ Go=
+ 0.00000000e+00
+ Rs=
+ 1.55902417e-03
+ Gd=
+ 2.04067990e-11

.Model Wmodel_Trace2257_Auto_96::MIPI_DSI0_DATA0_N W MODELTYPE=RLGC N=1
+ Lo=
+ 3.32029740e-07
+ Co=
+ 1.03489020e-10
+ Ro=
+ 3.96831067e+00
+ Go=
+ 0.00000000e+00
+ Rs=
+ 1.55902417e-03
+ Gd=
+ 2.04067990e-11

.Model Wmodel_Trace2257_Auto_99::MIPI_DSI0_DATA0_N W MODELTYPE=RLGC N=1
+ Lo=
+ 3.32029740e-07
+ Co=
+ 1.03489020e-10
+ Ro=
+ 3.96831067e+00
+ Go=
+ 0.00000000e+00
+ Rs=
+ 1.55902417e-03
+ Gd=
+ 2.04067990e-11

.Model Wmodel_Trace2277::MIPI_DSI0_DATA0_N W MODELTYPE=RLGC N=1
+ Lo=
+ 3.32029740e-07
+ Co=
+ 1.03489020e-10
+ Ro=
+ 3.96831067e+00
+ Go=
+ 0.00000000e+00
+ Rs=
+ 1.55902417e-03
+ Gd=
+ 2.04067990e-11

.Model Wmodel_Trace2279::MIPI_DSI0_DATA0_N W MODELTYPE=RLGC N=1
+ Lo=
+ 3.32029740e-07
+ Co=
+ 1.03489020e-10
+ Ro=
+ 3.96831067e+00
+ Go=
+ 0.00000000e+00
+ Rs=
+ 1.55902417e-03
+ Gd=
+ 2.04067990e-11

.Model Wmodel_Trace2280::MIPI_DSI0_DATA0_N W MODELTYPE=RLGC N=1
+ Lo=
+ 3.32029740e-07
+ Co=
+ 1.03489020e-10
+ Ro=
+ 3.96831067e+00
+ Go=
+ 0.00000000e+00
+ Rs=
+ 1.55902417e-03
+ Gd=
+ 2.04067990e-11

.Model Wmodel_Trace2280_Auto_78::MIPI_DSI0_DATA0_N W MODELTYPE=RLGC N=2
+ Lo=
+ 3.31094797e-07
+ 3.68987568e-08 3.31094797e-07
+ Co=
+ 1.03701156e-10
+ -3.66833433e-12 1.03701156e-10
+ Ro=
+ 3.96831067e+00
+ 0.00000000e+00 3.96831067e+00
+ Go=
+ 0.00000000e+00
+ -0.00000000e+00 0.00000000e+00
+ Rs=
+ 1.55902417e-03
+ -0.00000000e+00 1.55902417e-03
+ Gd=
+ 2.03865489e-11
+ -9.47735856e-14 2.03865489e-11

.Model Wmodel_Trace2280_Auto_80::MIPI_DSI0_DATA0_N W MODELTYPE=RLGC N=2
+ Lo=
+ 3.30748904e-07
+ 4.21593990e-08 3.30748904e-07
+ Co=
+ 1.03807716e-10
+ -4.52055469e-12 1.03807716e-10
+ Ro=
+ 3.96831067e+00
+ 0.00000000e+00 3.96831067e+00
+ Go=
+ 0.00000000e+00
+ -0.00000000e+00 0.00000000e+00
+ Rs=
+ 1.55902417e-03
+ -0.00000000e+00 1.55902417e-03
+ Gd=
+ 2.03827260e-11
+ -1.75097034e-13 2.03827260e-11

.Model Wmodel_Trace2281::MIPI_DSI0_DATA0_N W MODELTYPE=RLGC N=1
+ Lo=
+ 3.32029740e-07
+ Co=
+ 1.03489020e-10
+ Ro=
+ 3.96831067e+00
+ Go=
+ 0.00000000e+00
+ Rs=
+ 1.55902417e-03
+ Gd=
+ 2.04067990e-11

.Model Wmodel_Trace2282::MIPI_DSI0_DATA0_N W MODELTYPE=RLGC N=2
+ Lo=
+ 3.30794851e-07
+ 4.15141059e-08 3.30794851e-07
+ Co=
+ 1.03792936e-10
+ -4.41186360e-12 1.03792936e-10
+ Ro=
+ 3.96831067e+00
+ 0.00000000e+00 3.96831067e+00
+ Go=
+ 0.00000000e+00
+ -0.00000000e+00 0.00000000e+00
+ Rs=
+ 1.55902417e-03
+ -0.00000000e+00 1.55902417e-03
+ Gd=
+ 2.03831239e-11
+ -1.64270518e-13 2.03831239e-11

.Model Wmodel_Trace2286::MIPI_DSI0_DATA0_N W MODELTYPE=RLGC N=1
+ Lo=
+ 3.32029740e-07
+ Co=
+ 1.03489020e-10
+ Ro=
+ 3.96831067e+00
+ Go=
+ 0.00000000e+00
+ Rs=
+ 1.55902417e-03
+ Gd=
+ 2.04067990e-11

.Model Wmodel_Trace2289::MIPI_DSI0_DATA0_N W MODELTYPE=RLGC N=1
+ Lo=
+ 3.32029740e-07
+ Co=
+ 1.03489020e-10
+ Ro=
+ 3.96831067e+00
+ Go=
+ 0.00000000e+00
+ Rs=
+ 1.55902417e-03
+ Gd=
+ 2.04067990e-11

.Model Wmodel_Trace2290::MIPI_DSI0_DATA0_N W MODELTYPE=RLGC N=1
+ Lo=
+ 3.32029740e-07
+ Co=
+ 1.03489020e-10
+ Ro=
+ 3.96831067e+00
+ Go=
+ 0.00000000e+00
+ Rs=
+ 1.55902417e-03
+ Gd=
+ 2.04067990e-11

.Model Wmodel_Trace2291_Auto_1598::MIPI_DSI0_DATA0_N W MODELTYPE=RLGC N=1
+ Lo=
+ 3.32029740e-07
+ Co=
+ 1.03489020e-10
+ Ro=
+ 3.96831067e+00
+ Go=
+ 0.00000000e+00
+ Rs=
+ 1.55902417e-03
+ Gd=
+ 2.04067990e-11

.Model Wmodel_Trace2291_Auto_1600::MIPI_DSI0_DATA0_N W MODELTYPE=RLGC N=1
+ Lo=
+ 3.32029740e-07
+ Co=
+ 1.03489020e-10
+ Ro=
+ 3.96831067e+00
+ Go=
+ 0.00000000e+00
+ Rs=
+ 1.55902417e-03
+ Gd=
+ 2.04067990e-11

.Model Wmodel_Trace2293::MIPI_DSI0_DATA0_N W MODELTYPE=RLGC N=1
+ Lo=
+ 3.32029740e-07
+ Co=
+ 1.03489020e-10
+ Ro=
+ 3.96831067e+00
+ Go=
+ 0.00000000e+00
+ Rs=
+ 1.55902417e-03
+ Gd=
+ 2.04067990e-11

.Model Wmodel_Trace2295::MIPI_DSI0_DATA0_N W MODELTYPE=RLGC N=1
+ Lo=
+ 3.32029740e-07
+ Co=
+ 1.03489020e-10
+ Ro=
+ 3.96831067e+00
+ Go=
+ 0.00000000e+00
+ Rs=
+ 1.55902417e-03
+ Gd=
+ 2.04067990e-11

.Model Wmodel_Trace2295_Auto_1564::MIPI_DSI0_DATA0_N W MODELTYPE=RLGC N=1
+ Lo=
+ 3.32029740e-07
+ Co=
+ 1.03489020e-10
+ Ro=
+ 3.96831067e+00
+ Go=
+ 0.00000000e+00
+ Rs=
+ 1.55902417e-03
+ Gd=
+ 2.04067990e-11

.Model Wmodel_Trace2299::MIPI_DSI0_DATA0_N W MODELTYPE=RLGC N=1
+ Lo=
+ 3.32029740e-07
+ Co=
+ 1.03489020e-10
+ Ro=
+ 3.96831067e+00
+ Go=
+ 0.00000000e+00
+ Rs=
+ 1.55902417e-03
+ Gd=
+ 2.04067990e-11

.Model Wmodel_Trace2302_Auto_1860::MIPI_DSI0_DATA0_N W MODELTYPE=RLGC N=1
+ Lo=
+ 3.32029740e-07
+ Co=
+ 1.03489020e-10
+ Ro=
+ 3.96831067e+00
+ Go=
+ 0.00000000e+00
+ Rs=
+ 1.55902417e-03
+ Gd=
+ 2.04067990e-11

.Model Wmodel_Trace2303::MIPI_DSI0_DATA0_N W MODELTYPE=RLGC N=1
+ Lo=
+ 3.32029740e-07
+ Co=
+ 1.03489020e-10
+ Ro=
+ 3.96831067e+00
+ Go=
+ 0.00000000e+00
+ Rs=
+ 1.55902417e-03
+ Gd=
+ 2.04067990e-11

.Model Wmodel_Trace2311::MIPI_DSI0_DATA0_N W MODELTYPE=RLGC N=2
+ Lo=
+ 3.30680333e-07
+ 4.30971638e-08 3.30680333e-07
+ Co=
+ 1.03830101e-10
+ -4.68053370e-12 1.03830101e-10
+ Ro=
+ 3.96831067e+00
+ 0.00000000e+00 3.96831067e+00
+ Go=
+ 0.00000000e+00
+ -0.00000000e+00 0.00000000e+00
+ Rs=
+ 1.55902417e-03
+ -0.00000000e+00 1.55902417e-03
+ Gd=
+ 2.03821924e-11
+ -1.91305038e-13 2.03821924e-11

.Model Wmodel_Trace2311_Auto_1862::MIPI_DSI0_DATA0_N W MODELTYPE=RLGC N=1
+ Lo=
+ 3.32029740e-07
+ Co=
+ 1.03489020e-10
+ Ro=
+ 3.96831067e+00
+ Go=
+ 0.00000000e+00
+ Rs=
+ 1.55902417e-03
+ Gd=
+ 2.04067990e-11

.Model Wmodel_Trace2322::MIPI_DSI0_DATA0_N W MODELTYPE=RLGC N=1
+ Lo=
+ 3.32029740e-07
+ Co=
+ 1.03489020e-10
+ Ro=
+ 3.96831067e+00
+ Go=
+ 0.00000000e+00
+ Rs=
+ 1.55902417e-03
+ Gd=
+ 2.04067990e-11

.Model Wmodel_Trace2325_Auto_1858::MIPI_DSI0_DATA0_N W MODELTYPE=RLGC N=1
+ Lo=
+ 3.32029740e-07
+ Co=
+ 1.03489020e-10
+ Ro=
+ 3.96831067e+00
+ Go=
+ 0.00000000e+00
+ Rs=
+ 1.55902417e-03
+ Gd=
+ 2.04067990e-11

.Model Wmodel_Trace2326::MIPI_DSI0_DATA0_N W MODELTYPE=RLGC N=1
+ Lo=
+ 3.32029740e-07
+ Co=
+ 1.03489020e-10
+ Ro=
+ 3.96831067e+00
+ Go=
+ 0.00000000e+00
+ Rs=
+ 1.55902417e-03
+ Gd=
+ 2.04067990e-11

.Model Wmodel_Trace2335::MIPI_DSI0_DATA0_N W MODELTYPE=RLGC N=1
+ Lo=
+ 3.32029740e-07
+ Co=
+ 1.03489020e-10
+ Ro=
+ 3.96831067e+00
+ Go=
+ 0.00000000e+00
+ Rs=
+ 1.55902417e-03
+ Gd=
+ 2.04067990e-11

.Model Wmodel_Trace2339::MIPI_DSI0_DATA0_N W MODELTYPE=RLGC N=1
+ Lo=
+ 3.32029740e-07
+ Co=
+ 1.03489020e-10
+ Ro=
+ 3.96831067e+00
+ Go=
+ 0.00000000e+00
+ Rs=
+ 1.55902417e-03
+ Gd=
+ 2.04067990e-11

.Model Wmodel_Trace2344::MIPI_DSI0_DATA0_N W MODELTYPE=RLGC N=1
+ Lo=
+ 3.32029740e-07
+ Co=
+ 1.03489020e-10
+ Ro=
+ 3.96831067e+00
+ Go=
+ 0.00000000e+00
+ Rs=
+ 1.55902417e-03
+ Gd=
+ 2.04067990e-11

.Model Wmodel_Trace2351::MIPI_DSI0_CLK_P W MODELTYPE=RLGC N=1
+ Lo=
+ 3.32029740e-07
+ Co=
+ 1.03489020e-10
+ Ro=
+ 3.96831067e+00
+ Go=
+ 0.00000000e+00
+ Rs=
+ 1.55902417e-03
+ Gd=
+ 2.04067990e-11

.Model Wmodel_Trace2353::MIPI_DSI0_CLK_P W MODELTYPE=RLGC N=1
+ Lo=
+ 3.32029740e-07
+ Co=
+ 1.03489020e-10
+ Ro=
+ 3.96831067e+00
+ Go=
+ 0.00000000e+00
+ Rs=
+ 1.55902417e-03
+ Gd=
+ 2.04067990e-11

.Model Wmodel_Trace2362::MIPI_DSI0_CLK_P W MODELTYPE=RLGC N=1
+ Lo=
+ 3.32029740e-07
+ Co=
+ 1.03489020e-10
+ Ro=
+ 3.96831067e+00
+ Go=
+ 0.00000000e+00
+ Rs=
+ 1.55902417e-03
+ Gd=
+ 2.04067990e-11

.Model Wmodel_Trace2373::MIPI_DSI0_CLK_P W MODELTYPE=RLGC N=1
+ Lo=
+ 3.32029740e-07
+ Co=
+ 1.03489020e-10
+ Ro=
+ 3.96831067e+00
+ Go=
+ 0.00000000e+00
+ Rs=
+ 1.55902417e-03
+ Gd=
+ 2.04067990e-11

.Model Wmodel_Trace2375_Auto_118::MIPI_DSI0_CLK_P W MODELTYPE=RLGC N=2
+ Lo=
+ 3.30680616e-07
+ 4.30933520e-08 3.30680616e-07
+ Co=
+ 1.03830008e-10
+ -4.67987859e-12 1.03830008e-10
+ Ro=
+ 3.96831067e+00
+ 0.00000000e+00 3.96831067e+00
+ Go=
+ 0.00000000e+00
+ -0.00000000e+00 0.00000000e+00
+ Rs=
+ 1.55902417e-03
+ -0.00000000e+00 1.55902417e-03
+ Gd=
+ 2.03821945e-11
+ -1.91238025e-13 2.03821945e-11

.Model Wmodel_Trace2384::MIPI_DSI0_CLK_P W MODELTYPE=RLGC N=1
+ Lo=
+ 3.32029740e-07
+ Co=
+ 1.03489020e-10
+ Ro=
+ 3.96831067e+00
+ Go=
+ 0.00000000e+00
+ Rs=
+ 1.55902417e-03
+ Gd=
+ 2.04067990e-11

.Model Wmodel_Trace2386::MIPI_DSI0_CLK_P W MODELTYPE=RLGC N=1
+ Lo=
+ 3.32029740e-07
+ Co=
+ 1.03489020e-10
+ Ro=
+ 3.96831067e+00
+ Go=
+ 0.00000000e+00
+ Rs=
+ 1.55902417e-03
+ Gd=
+ 2.04067990e-11

.Model Wmodel_Trace2386_Auto_120::MIPI_DSI0_CLK_P W MODELTYPE=RLGC N=4
+ Lo=
+ 3.30624470e-07
+ 4.24162882e-08 3.29434799e-07
+ 1.17683986e-08 4.06913309e-08 3.29428032e-07
+ 5.23153085e-09 1.17844705e-08 4.25117884e-08 3.30617211e-07
+ Co=
+ 1.03827220e-10
+ -4.57794691e-12 1.04119187e-10
+ -5.23464548e-13 -4.29535874e-12 1.04121461e-10
+ -2.31326343e-13 -5.24013581e-13 -4.59431370e-12 1.03829535e-10
+ Ro=
+ 3.96831067e+00
+ 0.00000000e+00 3.96831067e+00
+ 0.00000000e+00 0.00000000e+00 3.96831067e+00
+ 0.00000000e+00 0.00000000e+00 0.00000000e+00 3.96831067e+00
+ Go=
+ 0.00000000e+00
+ -0.00000000e+00 0.00000000e+00
+ -0.00000000e+00 -0.00000000e+00 0.00000000e+00
+ -0.00000000e+00 -0.00000000e+00 -0.00000000e+00 0.00000000e+00
+ Rs=
+ 1.55902417e-03
+ -0.00000000e+00 1.55902417e-03
+ -0.00000000e+00 -0.00000000e+00 1.55902417e-03
+ -0.00000000e+00 -0.00000000e+00 -0.00000000e+00 1.55902417e-03
+ Gd=
+ 2.03815700e-11
+ -1.89294454e-13 2.03593302e-11
+ -0.00000000e+00 -1.68746954e-13 2.03592812e-11
+ -0.00000000e+00 -0.00000000e+00 -1.90963355e-13 2.03815152e-11

.Model Wmodel_Trace2396::MIPI_DSI0_CLK_P W MODELTYPE=RLGC N=1
+ Lo=
+ 3.32029740e-07
+ Co=
+ 1.03489020e-10
+ Ro=
+ 3.96831067e+00
+ Go=
+ 0.00000000e+00
+ Rs=
+ 1.55902417e-03
+ Gd=
+ 2.04067990e-11

.Model Wmodel_Trace2397::MIPI_DSI0_CLK_P W MODELTYPE=RLGC N=3
+ Lo=
+ 3.30118634e-07
+ 4.85987489e-08 3.28959425e-07
+ 1.30016401e-08 4.15884255e-08 3.30675665e-07
+ Co=
+ 1.04000649e-10
+ -5.68568678e-12 1.04302022e-10
+ -5.73257696e-13 -4.43805165e-12 1.03809096e-10
+ Ro=
+ 3.96831067e+00
+ 0.00000000e+00 3.96831067e+00
+ 0.00000000e+00 0.00000000e+00 3.96831067e+00
+ Go=
+ 0.00000000e+00
+ -0.00000000e+00 0.00000000e+00
+ -0.00000000e+00 -0.00000000e+00 0.00000000e+00
+ Rs=
+ 1.55902417e-03
+ -0.00000000e+00 1.55902417e-03
+ -0.00000000e+00 -0.00000000e+00 1.55902417e-03
+ Gd=
+ 2.03795952e-11
+ -3.08533908e-13 2.03577641e-11
+ -0.00000000e+00 -1.76939931e-13 2.03820818e-11

.Model Wmodel_Trace2397_Auto_294::MIPI_DSI0_CLK_P W MODELTYPE=RLGC N=1
+ Lo=
+ 3.32029740e-07
+ Co=
+ 1.03489020e-10
+ Ro=
+ 3.96831067e+00
+ Go=
+ 0.00000000e+00
+ Rs=
+ 1.55902417e-03
+ Gd=
+ 2.04067990e-11

.Model Wmodel_Trace2402::MIPI_DSI0_CLK_P W MODELTYPE=RLGC N=1
+ Lo=
+ 3.32029740e-07
+ Co=
+ 1.03489020e-10
+ Ro=
+ 3.96831067e+00
+ Go=
+ 0.00000000e+00
+ Rs=
+ 1.55902417e-03
+ Gd=
+ 2.04067990e-11

.Model Wmodel_Trace2403_Auto_211::MIPI_DSI0_CLK_P W MODELTYPE=RLGC N=1
+ Lo=
+ 3.32029740e-07
+ Co=
+ 1.03489020e-10
+ Ro=
+ 3.96831067e+00
+ Go=
+ 0.00000000e+00
+ Rs=
+ 1.55902417e-03
+ Gd=
+ 2.04067990e-11

.Model Wmodel_Trace2413::MIPI_DSI0_CLK_P W MODELTYPE=RLGC N=1
+ Lo=
+ 3.32029740e-07
+ Co=
+ 1.03489020e-10
+ Ro=
+ 3.96831067e+00
+ Go=
+ 0.00000000e+00
+ Rs=
+ 1.55902417e-03
+ Gd=
+ 2.04067990e-11

.Model Wmodel_Trace2416_Auto_210::MIPI_DSI0_CLK_P W MODELTYPE=RLGC N=1
+ Lo=
+ 3.32029740e-07
+ Co=
+ 1.03489020e-10
+ Ro=
+ 3.96831067e+00
+ Go=
+ 0.00000000e+00
+ Rs=
+ 1.55902417e-03
+ Gd=
+ 2.04067990e-11

.Model Wmodel_Trace2417::MIPI_DSI0_CLK_P W MODELTYPE=RLGC N=1
+ Lo=
+ 3.32029740e-07
+ Co=
+ 1.03489020e-10
+ Ro=
+ 3.96831067e+00
+ Go=
+ 0.00000000e+00
+ Rs=
+ 1.55902417e-03
+ Gd=
+ 2.04067990e-11

.Model Wmodel_Trace2421_Auto_199::MIPI_DSI0_CLK_P W MODELTYPE=RLGC N=1
+ Lo=
+ 3.32029740e-07
+ Co=
+ 1.03489020e-10
+ Ro=
+ 3.96831067e+00
+ Go=
+ 0.00000000e+00
+ Rs=
+ 1.55902417e-03
+ Gd=
+ 2.04067990e-11

.Model Wmodel_Trace2425::MIPI_DSI0_CLK_P W MODELTYPE=RLGC N=1
+ Lo=
+ 3.58484574e-07
+ Co=
+ 9.37055974e-11
+ Ro=
+ 4.84133902e+00
+ Go=
+ 0.00000000e+00
+ Rs=
+ 1.72420198e-03
+ Gd=
+ 1.82370500e-11

.Model Wmodel_Trace2432::MIPI_DSI0_CLK_P W MODELTYPE=RLGC N=1
+ Lo=
+ 3.32029740e-07
+ Co=
+ 1.03489020e-10
+ Ro=
+ 3.96831067e+00
+ Go=
+ 0.00000000e+00
+ Rs=
+ 1.55902417e-03
+ Gd=
+ 2.04067990e-11

.Model Wmodel_Trace2432_Auto_1295::MIPI_DSI0_CLK_P W MODELTYPE=RLGC N=1
+ Lo=
+ 3.32029740e-07
+ Co=
+ 1.03489020e-10
+ Ro=
+ 3.96831067e+00
+ Go=
+ 0.00000000e+00
+ Rs=
+ 1.55902417e-03
+ Gd=
+ 2.04067990e-11

.Model Wmodel_Trace2434::MIPI_DSI0_CLK_P W MODELTYPE=RLGC N=1
+ Lo=
+ 3.32029740e-07
+ Co=
+ 1.03489020e-10
+ Ro=
+ 3.96831067e+00
+ Go=
+ 0.00000000e+00
+ Rs=
+ 1.55902417e-03
+ Gd=
+ 2.04067990e-11

.Model Wmodel_Trace2435_Auto_1544::MIPI_DSI0_CLK_P W MODELTYPE=RLGC N=1
+ Lo=
+ 3.32029740e-07
+ Co=
+ 1.03489020e-10
+ Ro=
+ 3.96831067e+00
+ Go=
+ 0.00000000e+00
+ Rs=
+ 1.55902417e-03
+ Gd=
+ 2.04067990e-11

.Model Wmodel_Trace2435_Auto_1579::MIPI_DSI0_CLK_P W MODELTYPE=RLGC N=4
+ Lo=
+ 3.30672346e-07
+ 4.18899216e-08 3.29635356e-07
+ 1.12800067e-08 3.84130828e-08 3.29635356e-07
+ 5.05612937e-09 1.12800067e-08 4.18899216e-08 3.30672346e-07
+ Co=
+ 1.03813640e-10
+ -4.48692526e-12 1.04057968e-10
+ -5.08076612e-13 -3.92012358e-12 1.04057968e-10
+ -2.25050484e-13 -5.08076612e-13 -4.48692526e-12 1.03813640e-10
+ Ro=
+ 3.96831067e+00
+ 0.00000000e+00 3.96831067e+00
+ 0.00000000e+00 0.00000000e+00 3.96831067e+00
+ 0.00000000e+00 0.00000000e+00 0.00000000e+00 3.96831067e+00
+ Go=
+ 0.00000000e+00
+ -0.00000000e+00 0.00000000e+00
+ -0.00000000e+00 -0.00000000e+00 0.00000000e+00
+ -0.00000000e+00 -0.00000000e+00 -0.00000000e+00 0.00000000e+00
+ Rs=
+ 1.55902417e-03
+ -0.00000000e+00 1.55902417e-03
+ -0.00000000e+00 -0.00000000e+00 1.55902417e-03
+ -0.00000000e+00 -0.00000000e+00 -0.00000000e+00 1.55902417e-03
+ Gd=
+ 2.03819329e-11
+ -1.79370582e-13 2.03612081e-11
+ -0.00000000e+00 -1.32188560e-13 2.03612081e-11
+ -0.00000000e+00 -0.00000000e+00 -1.79370582e-13 2.03819329e-11

.Model Wmodel_Trace2435_Auto_1589::MIPI_DSI0_CLK_P W MODELTYPE=RLGC N=1
+ Lo=
+ 3.32029740e-07
+ Co=
+ 1.03489020e-10
+ Ro=
+ 3.96831067e+00
+ Go=
+ 0.00000000e+00
+ Rs=
+ 1.55902417e-03
+ Gd=
+ 2.04067990e-11

.Model Wmodel_Trace2435_Auto_1593::MIPI_DSI0_CLK_P W MODELTYPE=RLGC N=1
+ Lo=
+ 3.32029740e-07
+ Co=
+ 1.03489020e-10
+ Ro=
+ 3.96831067e+00
+ Go=
+ 0.00000000e+00
+ Rs=
+ 1.55902417e-03
+ Gd=
+ 2.04067990e-11

.Model Wmodel_Trace2436::MIPI_DSI0_CLK_P W MODELTYPE=RLGC N=2
+ Lo=
+ 3.31029499e-07
+ 3.79714376e-08 3.31029499e-07
+ Co=
+ 1.03720403e-10
+ -3.83576106e-12 1.03720403e-10
+ Ro=
+ 3.96831067e+00
+ 0.00000000e+00 3.96831067e+00
+ Go=
+ 0.00000000e+00
+ -0.00000000e+00 0.00000000e+00
+ Rs=
+ 1.55902417e-03
+ -0.00000000e+00 1.55902417e-03
+ Gd=
+ 2.03856779e-11
+ -1.09665525e-13 2.03856779e-11

.Model Wmodel_Trace2441::MIPI_DSI0_CLK_P W MODELTYPE=RLGC N=1
+ Lo=
+ 3.32029740e-07
+ Co=
+ 1.03489020e-10
+ Ro=
+ 3.96831067e+00
+ Go=
+ 0.00000000e+00
+ Rs=
+ 1.55902417e-03
+ Gd=
+ 2.04067990e-11

.Model Wmodel_Trace2453::MIPI_DSI0_CLK_P W MODELTYPE=RLGC N=1
+ Lo=
+ 3.32029740e-07
+ Co=
+ 1.03489020e-10
+ Ro=
+ 3.96831067e+00
+ Go=
+ 0.00000000e+00
+ Rs=
+ 1.55902417e-03
+ Gd=
+ 2.04067990e-11

.Model Wmodel_Trace2458::MIPI_DSI0_CLK_P W MODELTYPE=RLGC N=1
+ Lo=
+ 3.32029740e-07
+ Co=
+ 1.03489020e-10
+ Ro=
+ 3.96831067e+00
+ Go=
+ 0.00000000e+00
+ Rs=
+ 1.55902417e-03
+ Gd=
+ 2.04067990e-11

.Model Wmodel_Trace2460::MIPI_DSI0_CLK_P W MODELTYPE=RLGC N=2
+ Lo=
+ 3.31029544e-07
+ 3.79707129e-08 3.31029544e-07
+ Co=
+ 1.03720390e-10
+ -3.83564682e-12 1.03720390e-10
+ Ro=
+ 3.96831067e+00
+ 0.00000000e+00 3.96831067e+00
+ Go=
+ 0.00000000e+00
+ -0.00000000e+00 0.00000000e+00
+ Rs=
+ 1.55902417e-03
+ -0.00000000e+00 1.55902417e-03
+ Gd=
+ 2.03856785e-11
+ -1.09655203e-13 2.03856785e-11

.Model Wmodel_Trace2465::MIPI_DSI0_CLK_P W MODELTYPE=RLGC N=1
+ Lo=
+ 3.32029740e-07
+ Co=
+ 1.03489020e-10
+ Ro=
+ 3.96831067e+00
+ Go=
+ 0.00000000e+00
+ Rs=
+ 1.55902417e-03
+ Gd=
+ 2.04067990e-11

.Model Wmodel_Trace2477::MIPI_DSI0_CLK_P W MODELTYPE=RLGC N=1
+ Lo=
+ 3.32029740e-07
+ Co=
+ 1.03489020e-10
+ Ro=
+ 3.96831067e+00
+ Go=
+ 0.00000000e+00
+ Rs=
+ 1.55902417e-03
+ Gd=
+ 2.04067990e-11

.Model Wmodel_Trace2482::MIPI_DSI0_CLK_P W MODELTYPE=RLGC N=1
+ Lo=
+ 3.32029740e-07
+ Co=
+ 1.03489020e-10
+ Ro=
+ 3.96831067e+00
+ Go=
+ 0.00000000e+00
+ Rs=
+ 1.55902417e-03
+ Gd=
+ 2.04067990e-11

.Model Wmodel_Trace2484#BP0::MIPI_DSI0_CLK_P W MODELTYPE=RLGC N=2
+ Lo=
+ 3.31025165e-07
+ 3.80411482e-08 3.31025165e-07
+ Co=
+ 1.03721696e-10
+ -3.84675586e-12 1.03721696e-10
+ Ro=
+ 3.96831067e+00
+ 0.00000000e+00 3.96831067e+00
+ Go=
+ 0.00000000e+00
+ -0.00000000e+00 0.00000000e+00
+ Rs=
+ 1.55902417e-03
+ -0.00000000e+00 1.55902417e-03
+ Gd=
+ 2.03856226e-11
+ -1.10660017e-13 2.03856226e-11

.Model Wmodel_Trace2485::MIPI_DSI0_CLK_P W MODELTYPE=RLGC N=2
+ Lo=
+ 3.31133865e-07
+ 3.62354506e-08 3.31133865e-07
+ Co=
+ 1.03689850e-10
+ -3.56646590e-12 1.03689850e-10
+ Ro=
+ 3.96831067e+00
+ 0.00000000e+00 3.96831067e+00
+ Go=
+ 0.00000000e+00
+ -0.00000000e+00 0.00000000e+00
+ Rs=
+ 1.55902417e-03
+ -0.00000000e+00 1.55902417e-03
+ Gd=
+ 2.03871045e-11
+ -8.59531301e-14 2.03871045e-11

.Model Wmodel_Trace2487::MIPI_DSI0_CLK_P W MODELTYPE=RLGC N=1
+ Lo=
+ 3.32029740e-07
+ Co=
+ 1.03489020e-10
+ Ro=
+ 3.96831067e+00
+ Go=
+ 0.00000000e+00
+ Rs=
+ 1.55902417e-03
+ Gd=
+ 2.04067990e-11

.Model Wmodel_Trace2599::MIPI_DSI0_DATA2_P W MODELTYPE=RLGC N=1
+ Lo=
+ 3.32029740e-07
+ Co=
+ 1.03489020e-10
+ Ro=
+ 3.96831067e+00
+ Go=
+ 0.00000000e+00
+ Rs=
+ 1.55902417e-03
+ Gd=
+ 2.04067990e-11

.Model Wmodel_Trace2599_Auto_1393::MIPI_DSI0_DATA2_P W MODELTYPE=RLGC N=4
+ Lo=
+ 3.30714949e-07
+ 4.20671053e-08 3.30480245e-07
+ 7.61645646e-09 2.03795782e-08 3.30466404e-07
+ 3.87027388e-09 7.63361860e-09 4.22608067e-08 3.30700818e-07
+ Co=
+ 1.03810800e-10
+ -4.50958021e-12 1.03849578e-10
+ -3.66879932e-13 -1.51478292e-12 1.03854098e-10
+ -1.75756209e-13 -3.67525602e-13 -4.54244534e-12 1.03815346e-10
+ Ro=
+ 3.96831067e+00
+ 0.00000000e+00 3.96831067e+00
+ 0.00000000e+00 0.00000000e+00 3.96831067e+00
+ 0.00000000e+00 0.00000000e+00 0.00000000e+00 3.96831067e+00
+ Go=
+ 0.00000000e+00
+ -0.00000000e+00 0.00000000e+00
+ -0.00000000e+00 -0.00000000e+00 0.00000000e+00
+ -0.00000000e+00 -0.00000000e+00 -0.00000000e+00 0.00000000e+00
+ Rs=
+ 1.55902417e-03
+ -0.00000000e+00 1.55902417e-03
+ -0.00000000e+00 -0.00000000e+00 1.55902417e-03
+ -0.00000000e+00 -0.00000000e+00 -0.00000000e+00 1.55902417e-03
+ Gd=
+ 2.03822625e-11
+ -1.76791643e-13 2.03761983e-11
+ -0.00000000e+00 -0.00000000e+00 2.03760868e-11
+ -0.00000000e+00 -0.00000000e+00 -1.80097859e-13 2.03821467e-11

.Model Wmodel_Trace2599_Auto_1394::MIPI_DSI0_DATA2_P W MODELTYPE=RLGC N=1
+ Lo=
+ 3.32029740e-07
+ Co=
+ 1.03489020e-10
+ Ro=
+ 3.96831067e+00
+ Go=
+ 0.00000000e+00
+ Rs=
+ 1.55902417e-03
+ Gd=
+ 2.04067990e-11

.Model Wmodel_Trace2603::MIPI_DSI0_DATA2_P W MODELTYPE=RLGC N=1
+ Lo=
+ 3.32029740e-07
+ Co=
+ 1.03489020e-10
+ Ro=
+ 3.96831067e+00
+ Go=
+ 0.00000000e+00
+ Rs=
+ 1.55902417e-03
+ Gd=
+ 2.04067990e-11

.Model Wmodel_Trace2605::MIPI_DSI0_DATA2_P W MODELTYPE=RLGC N=1
+ Lo=
+ 3.32029740e-07
+ Co=
+ 1.03489020e-10
+ Ro=
+ 3.96831067e+00
+ Go=
+ 0.00000000e+00
+ Rs=
+ 1.55902417e-03
+ Gd=
+ 2.04067990e-11

.Model Wmodel_Trace2605_Auto_1241::MIPI_DSI0_DATA2_P W MODELTYPE=RLGC N=3
+ Lo=
+ 3.30682500e-07
+ 4.19037676e-08 3.29657895e-07
+ 1.14953743e-08 3.93242171e-08 3.30859039e-07
+ Co=
+ 1.03812690e-10
+ -4.48712756e-12 1.04065952e-10
+ -5.27101429e-13 -4.05934022e-12 1.03756935e-10
+ Ro=
+ 3.96831067e+00
+ 0.00000000e+00 3.96831067e+00
+ 0.00000000e+00 0.00000000e+00 3.96831067e+00
+ Go=
+ 0.00000000e+00
+ -0.00000000e+00 0.00000000e+00
+ -0.00000000e+00 -0.00000000e+00 0.00000000e+00
+ Rs=
+ 1.55902417e-03
+ -0.00000000e+00 1.55902417e-03
+ -0.00000000e+00 -0.00000000e+00 1.55902417e-03
+ Gd=
+ 2.03820519e-11
+ -1.79099615e-13 2.03613556e-11
+ -0.00000000e+00 -1.37963647e-13 2.03837636e-11

.Model Wmodel_Trace2605_Auto_1242::MIPI_DSI0_DATA2_P W MODELTYPE=RLGC N=1
+ Lo=
+ 3.32029740e-07
+ Co=
+ 1.03489020e-10
+ Ro=
+ 3.96831067e+00
+ Go=
+ 0.00000000e+00
+ Rs=
+ 1.55902417e-03
+ Gd=
+ 2.04067990e-11

.Model Wmodel_Trace2605_Auto_1243::MIPI_DSI0_DATA2_P W MODELTYPE=RLGC N=2
+ Lo=
+ 3.30715407e-07
+ 4.26211454e-08 3.30715407e-07
+ Co=
+ 1.03818602e-10
+ -4.59902819e-12 1.03818602e-10
+ Ro=
+ 3.96831067e+00
+ 0.00000000e+00 3.96831067e+00
+ Go=
+ 0.00000000e+00
+ -0.00000000e+00 0.00000000e+00
+ Rs=
+ 1.55902417e-03
+ -0.00000000e+00 1.55902417e-03
+ Gd=
+ 2.03824564e-11
+ -1.83007748e-13 2.03824564e-11

.Model Wmodel_Trace2607::MIPI_DSI0_DATA2_P W MODELTYPE=RLGC N=1
+ Lo=
+ 3.32029740e-07
+ Co=
+ 1.03489020e-10
+ Ro=
+ 3.96831067e+00
+ Go=
+ 0.00000000e+00
+ Rs=
+ 1.55902417e-03
+ Gd=
+ 2.04067990e-11

.Model Wmodel_Trace2611::MIPI_DSI0_DATA2_P W MODELTYPE=RLGC N=6
+ Lo=
+ 3.30662015e-07
+ 4.18472084e-08 3.29461457e-07
+ 1.16547780e-08 4.06511017e-08 3.29357941e-07
+ 5.13016412e-09 1.16288980e-08 4.19942167e-08 3.29225288e-07
+ 2.86306629e-09 5.13179599e-09 1.19476027e-08 4.24831512e-08 3.29291759e-07
+ 1.83816497e-09 2.87216138e-09 5.24586453e-09 1.20462687e-08 4.22823051e-08 3.30622599e-07
+ Co=
+ 1.03814255e-10
+ -4.48161290e-12 1.04106846e-10
+ -5.19028017e-13 -4.29159246e-12 1.04122543e-10
+ -2.20591955e-13 -5.06461407e-13 -4.52135584e-12 1.04165349e-10
+ -1.23940425e-13 -2.15251330e-13 -5.16966794e-13 -4.60372300e-12 1.04160636e-10
+ -8.32544670e-14 -1.24882065e-13 -2.25332578e-13 -5.31245278e-13 -4.55678609e-12 1.03825437e-10
+ Ro=
+ 3.96831067e+00
+ 0.00000000e+00 3.96831067e+00
+ 0.00000000e+00 0.00000000e+00 3.96831067e+00
+ 0.00000000e+00 0.00000000e+00 0.00000000e+00 3.96831067e+00
+ 0.00000000e+00 0.00000000e+00 0.00000000e+00 0.00000000e+00 3.96831067e+00
+ 0.00000000e+00 0.00000000e+00 0.00000000e+00 0.00000000e+00 0.00000000e+00 3.96831067e+00
+ Go=
+ 0.00000000e+00
+ -0.00000000e+00 0.00000000e+00
+ -0.00000000e+00 -0.00000000e+00 0.00000000e+00
+ -0.00000000e+00 -0.00000000e+00 -0.00000000e+00 0.00000000e+00
+ -0.00000000e+00 -0.00000000e+00 -0.00000000e+00 -0.00000000e+00 0.00000000e+00
+ -0.00000000e+00 -0.00000000e+00 -0.00000000e+00 -0.00000000e+00 -0.00000000e+00 0.00000000e+00
+ Rs=
+ 1.55902417e-03
+ -0.00000000e+00 1.55902417e-03
+ -0.00000000e+00 -0.00000000e+00 1.55902417e-03
+ -0.00000000e+00 -0.00000000e+00 -0.00000000e+00 1.55902417e-03
+ -0.00000000e+00 -0.00000000e+00 -0.00000000e+00 -0.00000000e+00 1.55902417e-03
+ -0.00000000e+00 -0.00000000e+00 -0.00000000e+00 -0.00000000e+00 -0.00000000e+00 1.55902417e-03
+ Gd=
+ 2.03818458e-11
+ -1.79694673e-13 2.03594940e-11
+ -0.00000000e+00 -1.68761202e-13 2.03586342e-11
+ -0.00000000e+00 -0.00000000e+00 -1.92124436e-13 2.03576063e-11
+ -0.00000000e+00 -0.00000000e+00 -0.00000000e+00 -2.00457887e-13 2.03581933e-11
+ -0.00000000e+00 -0.00000000e+00 -0.00000000e+00 -0.00000000e+00 -1.87871327e-13 2.03815462e-11

.Model Wmodel_Trace2611_Auto_1266::MIPI_DSI0_DATA2_P W MODELTYPE=RLGC N=1
+ Lo=
+ 3.32029740e-07
+ Co=
+ 1.03489020e-10
+ Ro=
+ 3.96831067e+00
+ Go=
+ 0.00000000e+00
+ Rs=
+ 1.55902417e-03
+ Gd=
+ 2.04067990e-11

.Model Wmodel_Trace2611_Auto_1270::MIPI_DSI0_DATA2_P W MODELTYPE=RLGC N=2
+ Lo=
+ 3.30714915e-07
+ 4.26278812e-08 3.30714915e-07
+ Co=
+ 1.03818763e-10
+ -4.60017723e-12 1.03818763e-10
+ Ro=
+ 3.96831067e+00
+ 0.00000000e+00 3.96831067e+00
+ Go=
+ 0.00000000e+00
+ -0.00000000e+00 0.00000000e+00
+ Rs=
+ 1.55902417e-03
+ -0.00000000e+00 1.55902417e-03
+ Gd=
+ 2.03824526e-11
+ -1.83124153e-13 2.03824526e-11

.Model Wmodel_Trace2611_Auto_1271::MIPI_DSI0_DATA2_P W MODELTYPE=RLGC N=1
+ Lo=
+ 3.32029740e-07
+ Co=
+ 1.03489020e-10
+ Ro=
+ 3.96831067e+00
+ Go=
+ 0.00000000e+00
+ Rs=
+ 1.55902417e-03
+ Gd=
+ 2.04067990e-11

.Model Wmodel_Trace2615::MIPI_DSI0_DATA2_P W MODELTYPE=RLGC N=1
+ Lo=
+ 3.32029740e-07
+ Co=
+ 1.03489020e-10
+ Ro=
+ 3.96831067e+00
+ Go=
+ 0.00000000e+00
+ Rs=
+ 1.55902417e-03
+ Gd=
+ 2.04067990e-11

.Model Wmodel_Trace2617::MIPI_DSI0_DATA2_P W MODELTYPE=RLGC N=1
+ Lo=
+ 3.32029740e-07
+ Co=
+ 1.03489020e-10
+ Ro=
+ 3.96831067e+00
+ Go=
+ 0.00000000e+00
+ Rs=
+ 1.55902417e-03
+ Gd=
+ 2.04067990e-11

.Model Wmodel_Trace2617_Auto_1252::MIPI_DSI0_DATA2_P W MODELTYPE=RLGC N=1
+ Lo=
+ 3.32029740e-07
+ Co=
+ 1.03489020e-10
+ Ro=
+ 3.96831067e+00
+ Go=
+ 0.00000000e+00
+ Rs=
+ 1.55902417e-03
+ Gd=
+ 2.04067990e-11

.Model Wmodel_Trace2621::MIPI_DSI0_DATA2_P W MODELTYPE=RLGC N=1
+ Lo=
+ 3.32029740e-07
+ Co=
+ 1.03489020e-10
+ Ro=
+ 3.96831067e+00
+ Go=
+ 0.00000000e+00
+ Rs=
+ 1.55902417e-03
+ Gd=
+ 2.04067990e-11

.Model Wmodel_Trace2623_Auto_1256::MIPI_DSI0_DATA2_P W MODELTYPE=RLGC N=3
+ Lo=
+ 3.30700752e-07
+ 4.15492032e-08 3.29506202e-07
+ 1.18805025e-08 4.18769793e-08 3.30677456e-07
+ Co=
+ 1.03805429e-10
+ -4.42817432e-12 1.04113701e-10
+ -5.39638913e-13 -4.48353292e-12 1.03812942e-10
+ Ro=
+ 3.96831067e+00
+ 0.00000000e+00 3.96831067e+00
+ 0.00000000e+00 0.00000000e+00 3.96831067e+00
+ Go=
+ 0.00000000e+00
+ -0.00000000e+00 0.00000000e+00
+ -0.00000000e+00 -0.00000000e+00 0.00000000e+00
+ Rs=
+ 1.55902417e-03
+ -0.00000000e+00 1.55902417e-03
+ -0.00000000e+00 -0.00000000e+00 1.55902417e-03
+ Gd=
+ 2.03822251e-11
+ -1.73930869e-13 2.03599307e-11
+ -0.00000000e+00 -1.79391374e-13 2.03820272e-11

.Model Wmodel_Trace2632::MIPI_DSI0_DATA2_P W MODELTYPE=RLGC N=1
+ Lo=
+ 3.32029740e-07
+ Co=
+ 1.03489020e-10
+ Ro=
+ 3.96831067e+00
+ Go=
+ 0.00000000e+00
+ Rs=
+ 1.55902417e-03
+ Gd=
+ 2.04067990e-11

.Model Wmodel_Trace2634_Auto_1258::MIPI_DSI0_DATA2_P W MODELTYPE=RLGC N=2
+ Lo=
+ 3.30748904e-07
+ 4.21593990e-08 3.30748904e-07
+ Co=
+ 1.03807716e-10
+ -4.52055469e-12 1.03807716e-10
+ Ro=
+ 3.96831067e+00
+ 0.00000000e+00 3.96831067e+00
+ Go=
+ 0.00000000e+00
+ -0.00000000e+00 0.00000000e+00
+ Rs=
+ 1.55902417e-03
+ -0.00000000e+00 1.55902417e-03
+ Gd=
+ 2.03827260e-11
+ -1.75097034e-13 2.03827260e-11

.Model Wmodel_Trace2636::MIPI_DSI0_DATA2_P W MODELTYPE=RLGC N=1
+ Lo=
+ 3.32029740e-07
+ Co=
+ 1.03489020e-10
+ Ro=
+ 3.96831067e+00
+ Go=
+ 0.00000000e+00
+ Rs=
+ 1.55902417e-03
+ Gd=
+ 2.04067990e-11

.Model Wmodel_Trace2638::MIPI_DSI0_DATA2_P W MODELTYPE=RLGC N=1
+ Lo=
+ 3.32029740e-07
+ Co=
+ 1.03489020e-10
+ Ro=
+ 3.96831067e+00
+ Go=
+ 0.00000000e+00
+ Rs=
+ 1.55902417e-03
+ Gd=
+ 2.04067990e-11

.Model Wmodel_Trace2638_Auto_1561::MIPI_DSI0_DATA2_P W MODELTYPE=RLGC N=2
+ Lo=
+ 3.30714848e-07
+ 4.26288028e-08 3.30714848e-07
+ Co=
+ 1.03818785e-10
+ -4.60033445e-12 1.03818785e-10
+ Ro=
+ 3.96831067e+00
+ 0.00000000e+00 3.96831067e+00
+ Go=
+ 0.00000000e+00
+ -0.00000000e+00 0.00000000e+00
+ Rs=
+ 1.55902417e-03
+ -0.00000000e+00 1.55902417e-03
+ Gd=
+ 2.03824521e-11
+ -1.83140082e-13 2.03824521e-11

.Model Wmodel_Trace2638_Auto_1562::MIPI_DSI0_DATA2_P W MODELTYPE=RLGC N=1
+ Lo=
+ 3.32029740e-07
+ Co=
+ 1.03489020e-10
+ Ro=
+ 3.96831067e+00
+ Go=
+ 0.00000000e+00
+ Rs=
+ 1.55902417e-03
+ Gd=
+ 2.04067990e-11

.Model Wmodel_Trace2640::MIPI_DSI0_DATA2_P W MODELTYPE=RLGC N=1
+ Lo=
+ 3.32029740e-07
+ Co=
+ 1.03489020e-10
+ Ro=
+ 3.96831067e+00
+ Go=
+ 0.00000000e+00
+ Rs=
+ 1.55902417e-03
+ Gd=
+ 2.04067990e-11

.Model Wmodel_Trace2642::MIPI_DSI0_DATA2_P W MODELTYPE=RLGC N=6
+ Lo=
+ 3.30693223e-07
+ 4.19876649e-08 3.30160293e-07
+ 9.47446802e-09 2.88714450e-08 3.30133141e-07
+ 4.47788311e-09 9.44512884e-09 4.18979449e-08 3.30414441e-07
+ 2.09950230e-09 3.39132780e-09 7.77271713e-09 2.11936368e-08 3.31182640e-07
+ 1.32083906e-09 1.90513739e-09 3.42843340e-09 6.50706838e-09 2.92716724e-08 3.31455302e-07
+ Co=
+ 1.03812412e-10
+ -4.49957770e-12 1.03916608e-10
+ -4.42846957e-13 -2.51907498e-12 1.03918964e-10
+ -1.99184766e-13 -4.38742314e-13 -4.48876692e-12 1.03857446e-10
+ -9.91193448e-14 -1.61475166e-13 -3.72454609e-13 -1.60507743e-12 1.03644224e-10
+ -6.28807868e-14 -9.01467899e-14 -1.59219691e-13 -3.25473113e-13 -2.57649229e-12 1.03599475e-10
+ Ro=
+ 3.96831067e+00
+ 0.00000000e+00 3.96831067e+00
+ 0.00000000e+00 0.00000000e+00 3.96831067e+00
+ 0.00000000e+00 0.00000000e+00 0.00000000e+00 3.96831067e+00
+ 0.00000000e+00 0.00000000e+00 0.00000000e+00 0.00000000e+00 3.96831067e+00
+ 0.00000000e+00 0.00000000e+00 0.00000000e+00 0.00000000e+00 0.00000000e+00 3.96831067e+00
+ Go=
+ 0.00000000e+00
+ -0.00000000e+00 0.00000000e+00
+ -0.00000000e+00 -0.00000000e+00 0.00000000e+00
+ -0.00000000e+00 -0.00000000e+00 -0.00000000e+00 0.00000000e+00
+ -0.00000000e+00 -0.00000000e+00 -0.00000000e+00 -0.00000000e+00 0.00000000e+00
+ -0.00000000e+00 -0.00000000e+00 -0.00000000e+00 -0.00000000e+00 -0.00000000e+00 0.00000000e+00
+ Rs=
+ 1.55902417e-03
+ -0.00000000e+00 1.55902417e-03
+ -0.00000000e+00 -0.00000000e+00 1.55902417e-03
+ -0.00000000e+00 -0.00000000e+00 -0.00000000e+00 1.55902417e-03
+ -0.00000000e+00 -0.00000000e+00 -0.00000000e+00 -0.00000000e+00 1.55902417e-03
+ -0.00000000e+00 -0.00000000e+00 -0.00000000e+00 -0.00000000e+00 -0.00000000e+00 1.55902417e-03
+ Gd=
+ 2.03820511e-11
+ -1.78008705e-13 2.03692349e-11
+ -0.00000000e+00 -1.96438152e-14 2.03688906e-11
+ -0.00000000e+00 -0.00000000e+00 -1.79647967e-13 2.03751320e-11
+ -0.00000000e+00 -0.00000000e+00 -0.00000000e+00 -0.00000000e+00 2.03859067e-11
+ -0.00000000e+00 -0.00000000e+00 -0.00000000e+00 -0.00000000e+00 -1.39911084e-14 2.03928137e-11

.Model Wmodel_Trace2642_Auto_1293::MIPI_DSI0_DATA2_P W MODELTYPE=RLGC N=1
+ Lo=
+ 3.32029740e-07
+ Co=
+ 1.03489020e-10
+ Ro=
+ 3.96831067e+00
+ Go=
+ 0.00000000e+00
+ Rs=
+ 1.55902417e-03
+ Gd=
+ 2.04067990e-11

.Model Wmodel_Trace2644_Auto_1034::MIPI_DSI0_DATA2_P W MODELTYPE=RLGC N=1
+ Lo=
+ 3.58484574e-07
+ Co=
+ 9.37055974e-11
+ Ro=
+ 4.84133902e+00
+ Go=
+ 0.00000000e+00
+ Rs=
+ 1.72420198e-03
+ Gd=
+ 1.82370500e-11

.Model Wmodel_Trace2645::MIPI_DSI0_DATA2_P W MODELTYPE=RLGC N=1
+ Lo=
+ 3.58484574e-07
+ Co=
+ 9.37055974e-11
+ Ro=
+ 4.84133902e+00
+ Go=
+ 0.00000000e+00
+ Rs=
+ 1.72420198e-03
+ Gd=
+ 1.82370500e-11

.Model Wmodel_Trace2647::MIPI_DSI0_DATA2_P W MODELTYPE=RLGC N=1
+ Lo=
+ 3.32029740e-07
+ Co=
+ 1.03489020e-10
+ Ro=
+ 3.96831067e+00
+ Go=
+ 0.00000000e+00
+ Rs=
+ 1.55902417e-03
+ Gd=
+ 2.04067990e-11

.Model Wmodel_Trace2647_Auto_186::MIPI_DSI0_DATA2_P W MODELTYPE=RLGC N=5
+ Lo=
+ 3.30630660e-07
+ 4.16716297e-08 3.28399687e-07
+ 1.36074655e-08 5.27664683e-08 3.28316730e-07
+ 5.62853813e-09 1.34483079e-08 4.12148912e-08 3.28201420e-07
+ 3.34062984e-09 6.34437988e-09 1.38485080e-08 5.50616644e-08 3.29439592e-07
+ Co=
+ 1.03815624e-10
+ -4.45944143e-12 1.04476165e-10
+ -5.75019854e-13 -6.52289720e-12 1.04481073e-10
+ -2.37392128e-13 -5.51706634e-13 -4.40099753e-12 1.04556591e-10
+ -1.42651495e-13 -2.48423122e-13 -5.75077791e-13 -6.95876643e-12 1.04247737e-10
+ Ro=
+ 3.96831067e+00
+ 0.00000000e+00 3.96831067e+00
+ 0.00000000e+00 0.00000000e+00 3.96831067e+00
+ 0.00000000e+00 0.00000000e+00 0.00000000e+00 3.96831067e+00
+ 0.00000000e+00 0.00000000e+00 0.00000000e+00 0.00000000e+00 3.96831067e+00
+ Go=
+ 0.00000000e+00
+ -0.00000000e+00 0.00000000e+00
+ -0.00000000e+00 -0.00000000e+00 0.00000000e+00
+ -0.00000000e+00 -0.00000000e+00 -0.00000000e+00 0.00000000e+00
+ -0.00000000e+00 -0.00000000e+00 -0.00000000e+00 -0.00000000e+00 0.00000000e+00
+ Rs=
+ 1.55902417e-03
+ -0.00000000e+00 1.55902417e-03
+ -0.00000000e+00 -0.00000000e+00 1.55902417e-03
+ -0.00000000e+00 -0.00000000e+00 -0.00000000e+00 1.55902417e-03
+ -0.00000000e+00 -0.00000000e+00 -0.00000000e+00 -0.00000000e+00 1.55902417e-03
+ Gd=
+ 2.03817252e-11
+ -1.81233289e-13 2.03579011e-11
+ -0.00000000e+00 -4.15916145e-13 2.03573297e-11
+ -0.00000000e+00 -0.00000000e+00 -1.86637918e-13 2.03592475e-11
+ -0.00000000e+00 -0.00000000e+00 -0.00000000e+00 -4.59630028e-13 2.03814841e-11

.Model Wmodel_Trace2647_Auto_191::MIPI_DSI0_DATA2_P W MODELTYPE=RLGC N=4
+ Lo=
+ 3.30635499e-07
+ 4.16812798e-08 3.28419595e-07
+ 1.36301794e-08 5.28161598e-08 3.28453607e-07
+ 5.68199859e-09 1.35217252e-08 4.11758254e-08 3.30673585e-07
+ Co=
+ 1.03815247e-10
+ -4.46010807e-12 1.04474975e-10
+ -5.76844965e-13 -6.52640320e-12 1.04463529e-10
+ -2.50640407e-13 -5.73315864e-13 -4.37452427e-12 1.03803470e-10
+ Ro=
+ 3.96831067e+00
+ 0.00000000e+00 3.96831067e+00
+ 0.00000000e+00 0.00000000e+00 3.96831067e+00
+ 0.00000000e+00 0.00000000e+00 0.00000000e+00 3.96831067e+00
+ Go=
+ 0.00000000e+00
+ -0.00000000e+00 0.00000000e+00
+ -0.00000000e+00 -0.00000000e+00 0.00000000e+00
+ -0.00000000e+00 -0.00000000e+00 -0.00000000e+00 0.00000000e+00
+ Rs=
+ 1.55902417e-03
+ -0.00000000e+00 1.55902417e-03
+ -0.00000000e+00 -0.00000000e+00 1.55902417e-03
+ -0.00000000e+00 -0.00000000e+00 -0.00000000e+00 1.55902417e-03
+ Gd=
+ 2.03817739e-11
+ -1.81151769e-13 2.03580383e-11
+ -0.00000000e+00 -4.15546015e-13 2.03583147e-11
+ -0.00000000e+00 -0.00000000e+00 -1.72563325e-13 2.03820930e-11

.Model Wmodel_Trace2647_Auto_192::MIPI_DSI0_DATA2_P W MODELTYPE=RLGC N=3
+ Lo=
+ 3.30649899e-07
+ 4.17175640e-08 3.28515414e-07
+ 1.37465549e-08 5.31443345e-08 3.29672936e-07
+ Co=
+ 1.03814120e-10
+ -4.46267989e-12 1.04469078e-10
+ -5.93486801e-13 -6.56540307e-12 1.04164827e-10
+ Ro=
+ 3.96831067e+00
+ 0.00000000e+00 3.96831067e+00
+ 0.00000000e+00 0.00000000e+00 3.96831067e+00
+ Go=
+ 0.00000000e+00
+ -0.00000000e+00 0.00000000e+00
+ -0.00000000e+00 -0.00000000e+00 0.00000000e+00
+ Rs=
+ 1.55902417e-03
+ -0.00000000e+00 1.55902417e-03
+ -0.00000000e+00 -0.00000000e+00 1.55902417e-03
+ Gd=
+ 2.03819256e-11
+ -1.80819369e-13 2.03587690e-11
+ -0.00000000e+00 -4.11226537e-13 2.03804809e-11

.Model Wmodel_Trace2647_Auto_193::MIPI_DSI0_DATA2_P W MODELTYPE=RLGC N=3
+ Lo=
+ 3.30649908e-07
+ 4.17176160e-08 3.28515759e-07
+ 1.37460332e-08 5.31409077e-08 3.29673293e-07
+ Co=
+ 1.03814120e-10
+ -4.46268651e-12 1.04468943e-10
+ -5.93473335e-13 -6.56472044e-12 1.04164691e-10
+ Ro=
+ 3.96831067e+00
+ 0.00000000e+00 3.96831067e+00
+ 0.00000000e+00 0.00000000e+00 3.96831067e+00
+ Go=
+ 0.00000000e+00
+ -0.00000000e+00 0.00000000e+00
+ -0.00000000e+00 -0.00000000e+00 0.00000000e+00
+ Rs=
+ 1.55902417e-03
+ -0.00000000e+00 1.55902417e-03
+ -0.00000000e+00 -0.00000000e+00 1.55902417e-03
+ Gd=
+ 2.03819256e-11
+ -1.80818974e-13 2.03587672e-11
+ -0.00000000e+00 -4.11144768e-13 2.03804792e-11

.Model Wmodel_Trace2647_Auto_202::MIPI_DSI0_DATA2_P W MODELTYPE=RLGC N=5
+ Lo=
+ 3.30631840e-07
+ 4.16743465e-08 3.28405955e-07
+ 1.36148331e-08 5.27836266e-08 3.28364487e-07
+ 5.66715227e-09 1.35415950e-08 4.14858761e-08 3.29855533e-07
+ 2.89482797e-09 5.19407322e-09 1.03978266e-08 3.40817025e-08 3.31168021e-07
+ Co=
+ 1.03815568e-10
+ -4.45956205e-12 1.04475915e-10
+ -5.75395360e-13 -6.52363801e-12 1.04478999e-10
+ -2.44715246e-13 -5.65228874e-13 -4.43566450e-12 1.03982710e-10
+ -1.32627125e-13 -2.21177516e-13 -4.71257190e-13 -3.24947285e-12 1.03666041e-10
+ Ro=
+ 3.96831067e+00
+ 0.00000000e+00 3.96831067e+00
+ 0.00000000e+00 0.00000000e+00 3.96831067e+00
+ 0.00000000e+00 0.00000000e+00 0.00000000e+00 3.96831067e+00
+ 0.00000000e+00 0.00000000e+00 0.00000000e+00 0.00000000e+00 3.96831067e+00
+ Go=
+ 0.00000000e+00
+ -0.00000000e+00 0.00000000e+00
+ -0.00000000e+00 -0.00000000e+00 0.00000000e+00
+ -0.00000000e+00 -0.00000000e+00 -0.00000000e+00 0.00000000e+00
+ -0.00000000e+00 -0.00000000e+00 -0.00000000e+00 -0.00000000e+00 0.00000000e+00
+ Rs=
+ 1.55902417e-03
+ -0.00000000e+00 1.55902417e-03
+ -0.00000000e+00 -0.00000000e+00 1.55902417e-03
+ -0.00000000e+00 -0.00000000e+00 -0.00000000e+00 1.55902417e-03
+ -0.00000000e+00 -0.00000000e+00 -0.00000000e+00 -0.00000000e+00 1.55902417e-03
+ Gd=
+ 2.03817288e-11
+ -1.81224735e-13 2.03579191e-11
+ -0.00000000e+00 -4.15856239e-13 2.03575088e-11
+ -0.00000000e+00 -0.00000000e+00 -1.84212028e-13 2.03645621e-11
+ -0.00000000e+00 -0.00000000e+00 -0.00000000e+00 -6.71743696e-14 2.03879464e-11

.Model Wmodel_Trace2647_Auto_203::MIPI_DSI0_DATA2_P W MODELTYPE=RLGC N=1
+ Lo=
+ 3.32029740e-07
+ Co=
+ 1.03489020e-10
+ Ro=
+ 3.96831067e+00
+ Go=
+ 0.00000000e+00
+ Rs=
+ 1.55902417e-03
+ Gd=
+ 2.04067990e-11

.Model Wmodel_Trace2647_Auto_228::MIPI_DSI0_DATA2_P W MODELTYPE=RLGC N=7
+ Lo=
+ 3.30629197e-07
+ 4.16699635e-08 3.28398495e-07
+ 1.36067849e-08 5.27693643e-08 3.28335530e-07
+ 5.64335420e-09 1.34954274e-08 4.13801026e-08 3.29382835e-07
+ 3.01207512e-09 5.52223347e-09 1.14180701e-08 4.01869607e-08 3.29392269e-07
+ 1.88358513e-09 2.97978297e-09 4.99647235e-09 1.14300349e-08 4.14074151e-08 3.28386411e-07
+ 1.37005911e-09 1.99889064e-09 3.01198197e-09 5.59284268e-09 1.36780128e-08 5.35476737e-08 3.29605781e-07
+ Co=
+ 1.03815791e-10
+ -4.45922961e-12 1.04476417e-10
+ -5.74788712e-13 -6.52270164e-12 1.04480816e-10
+ -2.41575350e-13 -5.59925389e-13 -4.42379329e-12 1.04104298e-10
+ -1.30542125e-13 -2.22778975e-13 -4.93906379e-13 -4.21835819e-12 1.04103592e-10
+ -8.08239825e-14 -1.18924594e-13 -2.03951529e-13 -4.94613533e-13 -4.42525368e-12 1.04492636e-10
+ -6.05262565e-14 -8.16892864e-14 -1.23848970e-13 -2.31582920e-13 -5.77817100e-13 -6.65112078e-12 1.04184185e-10
+ Ro=
+ 3.96831067e+00
+ 0.00000000e+00 3.96831067e+00
+ 0.00000000e+00 0.00000000e+00 3.96831067e+00
+ 0.00000000e+00 0.00000000e+00 0.00000000e+00 3.96831067e+00
+ 0.00000000e+00 0.00000000e+00 0.00000000e+00 0.00000000e+00 3.96831067e+00
+ 0.00000000e+00 0.00000000e+00 0.00000000e+00 0.00000000e+00 0.00000000e+00 3.96831067e+00
+ 0.00000000e+00 0.00000000e+00 0.00000000e+00 0.00000000e+00 0.00000000e+00 0.00000000e+00 3.96831067e+00
+ Go=
+ 0.00000000e+00
+ -0.00000000e+00 0.00000000e+00
+ -0.00000000e+00 -0.00000000e+00 0.00000000e+00
+ -0.00000000e+00 -0.00000000e+00 -0.00000000e+00 0.00000000e+00
+ -0.00000000e+00 -0.00000000e+00 -0.00000000e+00 -0.00000000e+00 0.00000000e+00
+ -0.00000000e+00 -0.00000000e+00 -0.00000000e+00 -0.00000000e+00 -0.00000000e+00 0.00000000e+00
+ -0.00000000e+00 -0.00000000e+00 -0.00000000e+00 -0.00000000e+00 -0.00000000e+00 -0.00000000e+00 0.00000000e+00
+ Rs=
+ 1.55902417e-03
+ -0.00000000e+00 1.55902417e-03
+ -0.00000000e+00 -0.00000000e+00 1.55902417e-03
+ -0.00000000e+00 -0.00000000e+00 -0.00000000e+00 1.55902417e-03
+ -0.00000000e+00 -0.00000000e+00 -0.00000000e+00 -0.00000000e+00 1.55902417e-03
+ -0.00000000e+00 -0.00000000e+00 -0.00000000e+00 -0.00000000e+00 -0.00000000e+00 1.55902417e-03
+ -0.00000000e+00 -0.00000000e+00 -0.00000000e+00 -0.00000000e+00 -0.00000000e+00 -0.00000000e+00 1.55902417e-03
+ Gd=
+ 2.03816993e-11
+ -1.81266403e-13 2.03578599e-11
+ -0.00000000e+00 -4.15964870e-13 2.03573007e-11
+ -0.00000000e+00 -0.00000000e+00 -1.85318749e-13 2.03589489e-11
+ -0.00000000e+00 -0.00000000e+00 -0.00000000e+00 -1.62000391e-13 2.03590396e-11
+ -0.00000000e+00 -0.00000000e+00 -0.00000000e+00 -0.00000000e+00 -1.85080672e-13 2.03582617e-11
+ -0.00000000e+00 -0.00000000e+00 -0.00000000e+00 -0.00000000e+00 -0.00000000e+00 -4.22270398e-13 2.03804978e-11

.Model Wmodel_Trace2647_Auto_229::MIPI_DSI0_DATA2_P W MODELTYPE=RLGC N=6
+ Lo=
+ 3.30629949e-07
+ 4.16710670e-08 3.28400120e-07
+ 1.36084587e-08 5.27718382e-08 3.28339314e-07
+ 5.64648680e-09 1.35000899e-08 4.13872965e-08 3.29396733e-07
+ 3.01973398e-09 5.53378661e-09 1.14361912e-08 4.02230058e-08 3.29490559e-07
+ 1.91188702e-09 3.02369791e-09 5.06767089e-09 1.15796955e-08 4.18519310e-08 3.30662682e-07
+ Co=
+ 1.03815724e-10
+ -4.45931907e-12 1.04476297e-10
+ -5.74924378e-13 -6.52288429e-12 1.04480538e-10
+ -2.41828830e-13 -5.60269419e-13 -4.42431295e-12 1.04103325e-10
+ -1.31171931e-13 -2.23627019e-13 -4.95199609e-13 -4.22078391e-12 1.04097516e-10
+ -8.64601300e-14 -1.26570455e-13 -2.15648222e-13 -5.16797416e-13 -4.48228931e-12 1.03814220e-10
+ Ro=
+ 3.96831067e+00
+ 0.00000000e+00 3.96831067e+00
+ 0.00000000e+00 0.00000000e+00 3.96831067e+00
+ 0.00000000e+00 0.00000000e+00 0.00000000e+00 3.96831067e+00
+ 0.00000000e+00 0.00000000e+00 0.00000000e+00 0.00000000e+00 3.96831067e+00
+ 0.00000000e+00 0.00000000e+00 0.00000000e+00 0.00000000e+00 0.00000000e+00 3.96831067e+00
+ Go=
+ 0.00000000e+00
+ -0.00000000e+00 0.00000000e+00
+ -0.00000000e+00 -0.00000000e+00 0.00000000e+00
+ -0.00000000e+00 -0.00000000e+00 -0.00000000e+00 0.00000000e+00
+ -0.00000000e+00 -0.00000000e+00 -0.00000000e+00 -0.00000000e+00 0.00000000e+00
+ -0.00000000e+00 -0.00000000e+00 -0.00000000e+00 -0.00000000e+00 -0.00000000e+00 0.00000000e+00
+ Rs=
+ 1.55902417e-03
+ -0.00000000e+00 1.55902417e-03
+ -0.00000000e+00 -0.00000000e+00 1.55902417e-03
+ -0.00000000e+00 -0.00000000e+00 -0.00000000e+00 1.55902417e-03
+ -0.00000000e+00 -0.00000000e+00 -0.00000000e+00 -0.00000000e+00 1.55902417e-03
+ -0.00000000e+00 -0.00000000e+00 -0.00000000e+00 -0.00000000e+00 -0.00000000e+00 1.55902417e-03
+ Gd=
+ 2.03817082e-11
+ -1.81254870e-13 2.03578747e-11
+ -0.00000000e+00 -4.15942462e-13 2.03573344e-11
+ -0.00000000e+00 -0.00000000e+00 -1.85255785e-13 2.03590668e-11
+ -0.00000000e+00 -0.00000000e+00 -0.00000000e+00 -1.61709269e-13 2.03597620e-11
+ -0.00000000e+00 -0.00000000e+00 -0.00000000e+00 -0.00000000e+00 -1.79639177e-13 2.03818501e-11

.Model Wmodel_Trace2647_Auto_234::MIPI_DSI0_DATA2_P W MODELTYPE=RLGC N=6
+ Lo=
+ 3.30629962e-07
+ 4.16710967e-08 3.28400186e-07
+ 1.36085354e-08 5.27720106e-08 3.28339773e-07
+ 5.64686137e-09 1.35009620e-08 4.13897192e-08 3.29410450e-07
+ 3.01513340e-09 5.52213822e-09 1.14020490e-08 4.00241730e-08 3.29496184e-07
+ 1.91092251e-09 3.02177114e-09 5.06348166e-09 1.15647740e-08 4.19719583e-08 3.30654393e-07
+ Co=
+ 1.03815724e-10
+ -4.45932067e-12 1.04476294e-10
+ -5.74928880e-13 -6.52289286e-12 1.04480516e-10
+ -2.41897154e-13 -5.60394120e-13 -4.42462465e-12 1.04099060e-10
+ -1.31040255e-13 -2.23304540e-13 -4.94070450e-13 -4.18776570e-12 1.04095964e-10
+ -8.63936755e-14 -1.26455015e-13 -2.15408198e-13 -5.16313111e-13 -4.50258183e-12 1.03816964e-10
+ Ro=
+ 3.96831067e+00
+ 0.00000000e+00 3.96831067e+00
+ 0.00000000e+00 0.00000000e+00 3.96831067e+00
+ 0.00000000e+00 0.00000000e+00 0.00000000e+00 3.96831067e+00
+ 0.00000000e+00 0.00000000e+00 0.00000000e+00 0.00000000e+00 3.96831067e+00
+ 0.00000000e+00 0.00000000e+00 0.00000000e+00 0.00000000e+00 0.00000000e+00 3.96831067e+00
+ Go=
+ 0.00000000e+00
+ -0.00000000e+00 0.00000000e+00
+ -0.00000000e+00 -0.00000000e+00 0.00000000e+00
+ -0.00000000e+00 -0.00000000e+00 -0.00000000e+00 0.00000000e+00
+ -0.00000000e+00 -0.00000000e+00 -0.00000000e+00 -0.00000000e+00 0.00000000e+00
+ -0.00000000e+00 -0.00000000e+00 -0.00000000e+00 -0.00000000e+00 -0.00000000e+00 0.00000000e+00
+ Rs=
+ 1.55902417e-03
+ -0.00000000e+00 1.55902417e-03
+ -0.00000000e+00 -0.00000000e+00 1.55902417e-03
+ -0.00000000e+00 -0.00000000e+00 -0.00000000e+00 1.55902417e-03
+ -0.00000000e+00 -0.00000000e+00 -0.00000000e+00 -0.00000000e+00 1.55902417e-03
+ -0.00000000e+00 -0.00000000e+00 -0.00000000e+00 -0.00000000e+00 -0.00000000e+00 1.55902417e-03
+ Gd=
+ 2.03817083e-11
+ -1.81254718e-13 2.03578750e-11
+ -0.00000000e+00 -4.15941655e-13 2.03573366e-11
+ -0.00000000e+00 -0.00000000e+00 -1.85231248e-13 2.03591945e-11
+ -0.00000000e+00 -0.00000000e+00 -0.00000000e+00 -1.58506789e-13 2.03598262e-11
+ -0.00000000e+00 -0.00000000e+00 -0.00000000e+00 -0.00000000e+00 -1.81624726e-13 2.03817812e-11

.Model Wmodel_Trace2647_Auto_240::MIPI_DSI0_DATA2_P W MODELTYPE=RLGC N=4
+ Lo=
+ 3.30636086e-07
+ 4.16844915e-08 3.28439378e-07
+ 1.36040243e-08 5.26398583e-08 3.28494900e-07
+ 5.65609025e-09 1.34262974e-08 4.08549445e-08 3.30698239e-07
+ Co=
+ 1.03815223e-10
+ -4.46048034e-12 1.04467785e-10
+ -5.76362994e-13 -6.49083241e-12 1.04449162e-10
+ -2.49852346e-13 -5.70561506e-13 -4.32040095e-12 1.03796060e-10
+ Ro=
+ 3.96831067e+00
+ 0.00000000e+00 3.96831067e+00
+ 0.00000000e+00 0.00000000e+00 3.96831067e+00
+ 0.00000000e+00 0.00000000e+00 0.00000000e+00 3.96831067e+00
+ Go=
+ 0.00000000e+00
+ -0.00000000e+00 0.00000000e+00
+ -0.00000000e+00 -0.00000000e+00 0.00000000e+00
+ -0.00000000e+00 -0.00000000e+00 -0.00000000e+00 0.00000000e+00
+ Rs=
+ 1.55902417e-03
+ -0.00000000e+00 1.55902417e-03
+ -0.00000000e+00 -0.00000000e+00 1.55902417e-03
+ -0.00000000e+00 -0.00000000e+00 -0.00000000e+00 1.55902417e-03
+ Gd=
+ 2.03817759e-11
+ -1.81128782e-13 2.03579503e-11
+ -0.00000000e+00 -4.11167969e-13 2.03584120e-11
+ -0.00000000e+00 -0.00000000e+00 -1.67121891e-13 2.03823075e-11

.Model Wmodel_Trace2647_Auto_241::MIPI_DSI0_DATA2_P W MODELTYPE=RLGC N=3
+ Lo=
+ 3.30659914e-07
+ 4.17779300e-08 3.28906782e-07
+ 1.31085965e-08 4.90304062e-08 3.30077944e-07
+ Co=
+ 1.03813728e-10
+ -4.47044843e-12 1.04320677e-10
+ -5.76361489e-13 -5.76712200e-12 1.04014978e-10
+ Ro=
+ 3.96831067e+00
+ 0.00000000e+00 3.96831067e+00
+ 0.00000000e+00 0.00000000e+00 3.96831067e+00
+ Go=
+ 0.00000000e+00
+ -0.00000000e+00 0.00000000e+00
+ -0.00000000e+00 -0.00000000e+00 0.00000000e+00
+ Rs=
+ 1.55902417e-03
+ -0.00000000e+00 1.55902417e-03
+ -0.00000000e+00 -0.00000000e+00 1.55902417e-03
+ Gd=
+ 2.03819568e-11
+ -1.80333301e-13 2.03576592e-11
+ -0.00000000e+00 -3.17849680e-13 2.03795755e-11

.Model Wmodel_Trace2647_Auto_243::MIPI_DSI0_DATA2_P W MODELTYPE=RLGC N=2
+ Lo=
+ 3.30748904e-07
+ 4.21593990e-08 3.30748904e-07
+ Co=
+ 1.03807716e-10
+ -4.52055469e-12 1.03807716e-10
+ Ro=
+ 3.96831067e+00
+ 0.00000000e+00 3.96831067e+00
+ Go=
+ 0.00000000e+00
+ -0.00000000e+00 0.00000000e+00
+ Rs=
+ 1.55902417e-03
+ -0.00000000e+00 1.55902417e-03
+ Gd=
+ 2.03827260e-11
+ -1.75097034e-13 2.03827260e-11

.Model Wmodel_Trace2647_Auto_262::MIPI_DSI0_DATA2_P W MODELTYPE=RLGC N=7
+ Lo=
+ 3.30629197e-07
+ 4.16699628e-08 3.28398494e-07
+ 1.36067836e-08 5.27693622e-08 3.28335526e-07
+ 5.64335125e-09 1.34954226e-08 4.13800943e-08 3.29382816e-07
+ 3.01206529e-09 5.52221733e-09 1.14180421e-08 4.01868951e-08 3.29392041e-07
+ 1.88353209e-09 2.97969366e-09 4.99631344e-09 1.14296475e-08 4.14059928e-08 3.28376864e-07
+ 1.37047931e-09 1.99965395e-09 3.01342503e-09 5.59656944e-09 1.36921072e-08 5.36412870e-08 3.29595884e-07
+ Co=
+ 1.03815791e-10
+ -4.45922959e-12 1.04476418e-10
+ -5.74788672e-13 -6.52270158e-12 1.04480816e-10
+ -2.41575240e-13 -5.59925221e-13 -4.42379300e-12 1.04104298e-10
+ -1.30541653e-13 -2.22778289e-13 -4.93905237e-13 -4.21835571e-12 1.04103600e-10
+ -8.08102244e-14 -1.18905437e-13 -2.03921284e-13 -4.94552733e-13 -4.42507643e-12 1.04496396e-10
+ -6.05289468e-14 -8.16973889e-14 -1.23870328e-13 -2.31653987e-13 -5.78174972e-13 -6.66988802e-12 1.04187980e-10
+ Ro=
+ 3.96831067e+00
+ 0.00000000e+00 3.96831067e+00
+ 0.00000000e+00 0.00000000e+00 3.96831067e+00
+ 0.00000000e+00 0.00000000e+00 0.00000000e+00 3.96831067e+00
+ 0.00000000e+00 0.00000000e+00 0.00000000e+00 0.00000000e+00 3.96831067e+00
+ 0.00000000e+00 0.00000000e+00 0.00000000e+00 0.00000000e+00 0.00000000e+00 3.96831067e+00
+ 0.00000000e+00 0.00000000e+00 0.00000000e+00 0.00000000e+00 0.00000000e+00 0.00000000e+00 3.96831067e+00
+ Go=
+ 0.00000000e+00
+ -0.00000000e+00 0.00000000e+00
+ -0.00000000e+00 -0.00000000e+00 0.00000000e+00
+ -0.00000000e+00 -0.00000000e+00 -0.00000000e+00 0.00000000e+00
+ -0.00000000e+00 -0.00000000e+00 -0.00000000e+00 -0.00000000e+00 0.00000000e+00
+ -0.00000000e+00 -0.00000000e+00 -0.00000000e+00 -0.00000000e+00 -0.00000000e+00 0.00000000e+00
+ -0.00000000e+00 -0.00000000e+00 -0.00000000e+00 -0.00000000e+00 -0.00000000e+00 -0.00000000e+00 0.00000000e+00
+ Rs=
+ 1.55902417e-03
+ -0.00000000e+00 1.55902417e-03
+ -0.00000000e+00 -0.00000000e+00 1.55902417e-03
+ -0.00000000e+00 -0.00000000e+00 -0.00000000e+00 1.55902417e-03
+ -0.00000000e+00 -0.00000000e+00 -0.00000000e+00 -0.00000000e+00 1.55902417e-03
+ -0.00000000e+00 -0.00000000e+00 -0.00000000e+00 -0.00000000e+00 -0.00000000e+00 1.55902417e-03
+ -0.00000000e+00 -0.00000000e+00 -0.00000000e+00 -0.00000000e+00 -0.00000000e+00 -0.00000000e+00 1.55902417e-03
+ Gd=
+ 2.03816993e-11
+ -1.81266402e-13 2.03578599e-11
+ -0.00000000e+00 -4.15964870e-13 2.03573007e-11
+ -0.00000000e+00 -0.00000000e+00 -1.85318760e-13 2.03589489e-11
+ -0.00000000e+00 -0.00000000e+00 -0.00000000e+00 -1.62000550e-13 2.03590390e-11
+ -0.00000000e+00 -0.00000000e+00 -0.00000000e+00 -0.00000000e+00 -1.85090680e-13 2.03583173e-11
+ -0.00000000e+00 -0.00000000e+00 -0.00000000e+00 -0.00000000e+00 -0.00000000e+00 -4.24530307e-13 2.03805485e-11

.Model Wmodel_Trace2647_Auto_267::MIPI_DSI0_DATA2_P W MODELTYPE=RLGC N=4
+ Lo=
+ 3.30638229e-07
+ 4.16981447e-08 3.28531214e-07
+ 1.34541259e-08 5.16760642e-08 3.28499501e-07
+ 5.69141507e-09 1.35509859e-08 4.21604663e-08 3.30602906e-07
+ Co=
+ 1.03815140e-10
+ -4.46227307e-12 1.04431567e-10
+ -5.71797157e-13 -6.30132671e-12 1.04442315e-10
+ -2.50272133e-13 -5.74945885e-13 -4.54115899e-12 1.03826182e-10
+ Ro=
+ 3.96831067e+00
+ 0.00000000e+00 3.96831067e+00
+ 0.00000000e+00 0.00000000e+00 3.96831067e+00
+ 0.00000000e+00 0.00000000e+00 0.00000000e+00 3.96831067e+00
+ Go=
+ 0.00000000e+00
+ -0.00000000e+00 0.00000000e+00
+ -0.00000000e+00 -0.00000000e+00 0.00000000e+00
+ -0.00000000e+00 -0.00000000e+00 -0.00000000e+00 0.00000000e+00
+ Rs=
+ 1.55902417e-03
+ -0.00000000e+00 1.55902417e-03
+ -0.00000000e+00 -0.00000000e+00 1.55902417e-03
+ -0.00000000e+00 -0.00000000e+00 -0.00000000e+00 1.55902417e-03
+ Gd=
+ 2.03817828e-11
+ -1.81020260e-13 2.03575256e-11
+ -0.00000000e+00 -3.89030296e-13 2.03572855e-11
+ -0.00000000e+00 -0.00000000e+00 -1.89017179e-13 2.03815047e-11

.Model Wmodel_Trace2647_Auto_269::MIPI_DSI0_DATA2_P W MODELTYPE=RLGC N=3
+ Lo=
+ 3.30665176e-07
+ 4.18085621e-08 3.29098185e-07
+ 1.27563865e-08 4.68253176e-08 3.30276432e-07
+ Co=
+ 1.03813506e-10
+ -4.47445409e-12 1.04251692e-10
+ -5.66337311e-13 -5.35704508e-12 1.03945226e-10
+ Ro=
+ 3.96831067e+00
+ 0.00000000e+00 3.96831067e+00
+ 0.00000000e+00 0.00000000e+00 3.96831067e+00
+ Go=
+ 0.00000000e+00
+ -0.00000000e+00 0.00000000e+00
+ -0.00000000e+00 -0.00000000e+00 0.00000000e+00
+ Rs=
+ 1.55902417e-03
+ -0.00000000e+00 1.55902417e-03
+ -0.00000000e+00 -0.00000000e+00 1.55902417e-03
+ Gd=
+ 2.03819756e-11
+ -1.80062864e-13 2.03578329e-11
+ -0.00000000e+00 -2.71860027e-13 2.03798599e-11

.Model Wmodel_Trace2648::MIPI_DSI0_DATA2_P W MODELTYPE=RLGC N=1
+ Lo=
+ 3.32029740e-07
+ Co=
+ 1.03489020e-10
+ Ro=
+ 3.96831067e+00
+ Go=
+ 0.00000000e+00
+ Rs=
+ 1.55902417e-03
+ Gd=
+ 2.04067990e-11

.Model Wmodel_Trace2648_Auto_285::MIPI_DSI0_DATA2_P W MODELTYPE=RLGC N=1
+ Lo=
+ 3.32029740e-07
+ Co=
+ 1.03489020e-10
+ Ro=
+ 3.96831067e+00
+ Go=
+ 0.00000000e+00
+ Rs=
+ 1.55902417e-03
+ Gd=
+ 2.04067990e-11

.Model Wmodel_Trace2650::MIPI_DSI0_DATA2_P W MODELTYPE=RLGC N=1
+ Lo=
+ 3.32029740e-07
+ Co=
+ 1.03489020e-10
+ Ro=
+ 3.96831067e+00
+ Go=
+ 0.00000000e+00
+ Rs=
+ 1.55902417e-03
+ Gd=
+ 2.04067990e-11

.Model Wmodel_Trace2660::MIPI_DSI0_DATA2_P W MODELTYPE=RLGC N=1
+ Lo=
+ 3.32029740e-07
+ Co=
+ 1.03489020e-10
+ Ro=
+ 3.96831067e+00
+ Go=
+ 0.00000000e+00
+ Rs=
+ 1.55902417e-03
+ Gd=
+ 2.04067990e-11

.Model Wmodel_Trace2662::MIPI_DSI0_DATA2_P W MODELTYPE=RLGC N=2
+ Lo=
+ 3.30680783e-07
+ 4.30911130e-08 3.30680783e-07
+ Co=
+ 1.03829953e-10
+ -4.67949380e-12 1.03829953e-10
+ Ro=
+ 3.96831067e+00
+ 0.00000000e+00 3.96831067e+00
+ Go=
+ 0.00000000e+00
+ -0.00000000e+00 0.00000000e+00
+ Rs=
+ 1.55902417e-03
+ -0.00000000e+00 1.55902417e-03
+ Gd=
+ 2.03821957e-11
+ -1.91198666e-13 2.03821957e-11

.Model Wmodel_Trace2663::MIPI_DSI0_DATA2_P W MODELTYPE=RLGC N=1
+ Lo=
+ 3.32029740e-07
+ Co=
+ 1.03489020e-10
+ Ro=
+ 3.96831067e+00
+ Go=
+ 0.00000000e+00
+ Rs=
+ 1.55902417e-03
+ Gd=
+ 2.04067990e-11

.Model Wmodel_Trace2666::MIPI_DSI0_DATA2_P W MODELTYPE=RLGC N=1
+ Lo=
+ 3.32029740e-07
+ Co=
+ 1.03489020e-10
+ Ro=
+ 3.96831067e+00
+ Go=
+ 0.00000000e+00
+ Rs=
+ 1.55902417e-03
+ Gd=
+ 2.04067990e-11

.Model Wmodel_Trace2667::MIPI_DSI0_DATA2_P W MODELTYPE=RLGC N=1
+ Lo=
+ 3.32029740e-07
+ Co=
+ 1.03489020e-10
+ Ro=
+ 3.96831067e+00
+ Go=
+ 0.00000000e+00
+ Rs=
+ 1.55902417e-03
+ Gd=
+ 2.04067990e-11

.Model Wmodel_Trace2669::MIPI_DSI0_DATA2_P W MODELTYPE=RLGC N=1
+ Lo=
+ 3.32029740e-07
+ Co=
+ 1.03489020e-10
+ Ro=
+ 3.96831067e+00
+ Go=
+ 0.00000000e+00
+ Rs=
+ 1.55902417e-03
+ Gd=
+ 2.04067990e-11

.Model Wmodel_Trace2671::MIPI_DSI0_DATA1_P W MODELTYPE=RLGC N=1
+ Lo=
+ 3.32029740e-07
+ Co=
+ 1.03489020e-10
+ Ro=
+ 3.96831067e+00
+ Go=
+ 0.00000000e+00
+ Rs=
+ 1.55902417e-03
+ Gd=
+ 2.04067990e-11

.Model Wmodel_Trace2671_Auto_1290::MIPI_DSI0_DATA1_P W MODELTYPE=RLGC N=1
+ Lo=
+ 3.32029740e-07
+ Co=
+ 1.03489020e-10
+ Ro=
+ 3.96831067e+00
+ Go=
+ 0.00000000e+00
+ Rs=
+ 1.55902417e-03
+ Gd=
+ 2.04067990e-11

.Model Wmodel_Trace2672_Auto_1539::MIPI_DSI0_DATA1_P W MODELTYPE=RLGC N=3
+ Lo=
+ 3.30663320e-07
+ 4.18049009e-08 3.29044781e-07
+ 1.28580738e-08 4.74511741e-08 3.30221370e-07
+ Co=
+ 1.03813685e-10
+ -4.47416362e-12 1.04270674e-10
+ -5.69275362e-13 -5.47215384e-12 1.03964311e-10
+ Ro=
+ 3.96831067e+00
+ 0.00000000e+00 3.96831067e+00
+ 0.00000000e+00 0.00000000e+00 3.96831067e+00
+ Go=
+ 0.00000000e+00
+ -0.00000000e+00 0.00000000e+00
+ -0.00000000e+00 -0.00000000e+00 0.00000000e+00
+ Rs=
+ 1.55902417e-03
+ -0.00000000e+00 1.55902417e-03
+ -0.00000000e+00 -0.00000000e+00 1.55902417e-03
+ Gd=
+ 2.03819671e-11
+ -1.80224448e-13 2.03577325e-11
+ -0.00000000e+00 -2.84619526e-13 2.03797306e-11

.Model Wmodel_Trace2672_Auto_1540::MIPI_DSI0_DATA1_P W MODELTYPE=RLGC N=3
+ Lo=
+ 3.30657959e-07
+ 4.17734730e-08 3.28846914e-07
+ 1.32131430e-08 4.96877637e-08 3.30016269e-07
+ Co=
+ 1.03813908e-10
+ -4.47006636e-12 1.04342743e-10
+ -5.79261740e-13 -5.89180328e-12 1.04037161e-10
+ Ro=
+ 3.96831067e+00
+ 0.00000000e+00 3.96831067e+00
+ 0.00000000e+00 0.00000000e+00 3.96831067e+00
+ Go=
+ 0.00000000e+00
+ -0.00000000e+00 0.00000000e+00
+ -0.00000000e+00 -0.00000000e+00 0.00000000e+00
+ Rs=
+ 1.55902417e-03
+ -0.00000000e+00 1.55902417e-03
+ -0.00000000e+00 -0.00000000e+00 1.55902417e-03
+ Gd=
+ 2.03819484e-11
+ -1.80496800e-13 2.03577014e-11
+ -0.00000000e+00 -3.32118849e-13 2.03795874e-11

.Model Wmodel_Trace2672_Auto_1556::MIPI_DSI0_DATA1_P W MODELTYPE=RLGC N=2
+ Lo=
+ 3.30748548e-07
+ 4.21643405e-08 3.30748548e-07
+ Co=
+ 1.03807831e-10
+ -4.52139143e-12 1.03807831e-10
+ Ro=
+ 3.96831067e+00
+ 0.00000000e+00 3.96831067e+00
+ Go=
+ 0.00000000e+00
+ -0.00000000e+00 0.00000000e+00
+ Rs=
+ 1.55902417e-03
+ -0.00000000e+00 1.55902417e-03
+ Gd=
+ 2.03827231e-11
+ -1.75180973e-13 2.03827231e-11

.Model Wmodel_Trace2672_Auto_1586::MIPI_DSI0_DATA1_P W MODELTYPE=RLGC N=4
+ Lo=
+ 3.30627437e-07
+ 4.20086203e-08 3.28832100e-07
+ 1.29901375e-08 4.83663902e-08 3.28849622e-07
+ 5.54076860e-09 1.29398002e-08 4.17539089e-08 3.30646726e-07
+ Co=
+ 1.03820925e-10
+ -4.51283201e-12 1.04321073e-10
+ -5.59851065e-13 -5.66308371e-12 1.04315176e-10
+ -2.44413409e-13 -5.58184901e-13 -4.46946498e-12 1.03814881e-10
+ Ro=
+ 3.96831067e+00
+ 0.00000000e+00 3.96831067e+00
+ 0.00000000e+00 0.00000000e+00 3.96831067e+00
+ 0.00000000e+00 0.00000000e+00 0.00000000e+00 3.96831067e+00
+ Go=
+ 0.00000000e+00
+ -0.00000000e+00 0.00000000e+00
+ -0.00000000e+00 -0.00000000e+00 0.00000000e+00
+ -0.00000000e+00 -0.00000000e+00 -0.00000000e+00 0.00000000e+00
+ Rs=
+ 1.55902417e-03
+ -0.00000000e+00 1.55902417e-03
+ -0.00000000e+00 -0.00000000e+00 1.55902417e-03
+ -0.00000000e+00 -0.00000000e+00 -0.00000000e+00 1.55902417e-03
+ Gd=
+ 2.03816578e-11
+ -1.85077858e-13 2.03568133e-11
+ -0.00000000e+00 -3.14801200e-13 2.03569485e-11
+ -0.00000000e+00 -0.00000000e+00 -1.80693543e-13 2.03818123e-11

.Model Wmodel_Trace2676::MIPI_DSI0_DATA1_P W MODELTYPE=RLGC N=1
+ Lo=
+ 3.32029740e-07
+ Co=
+ 1.03489020e-10
+ Ro=
+ 3.96831067e+00
+ Go=
+ 0.00000000e+00
+ Rs=
+ 1.55902417e-03
+ Gd=
+ 2.04067990e-11

.Model Wmodel_Trace2678_Auto_1381::MIPI_DSI0_DATA1_P W MODELTYPE=RLGC N=1
+ Lo=
+ 3.32029740e-07
+ Co=
+ 1.03489020e-10
+ Ro=
+ 3.96831067e+00
+ Go=
+ 0.00000000e+00
+ Rs=
+ 1.55902417e-03
+ Gd=
+ 2.04067990e-11

.Model Wmodel_Trace2687::MIPI_DSI0_DATA1_P W MODELTYPE=RLGC N=1
+ Lo=
+ 3.32029740e-07
+ Co=
+ 1.03489020e-10
+ Ro=
+ 3.96831067e+00
+ Go=
+ 0.00000000e+00
+ Rs=
+ 1.55902417e-03
+ Gd=
+ 2.04067990e-11

.Model Wmodel_Trace2689::MIPI_DSI0_DATA1_P W MODELTYPE=RLGC N=2
+ Lo=
+ 3.30744594e-07
+ 4.22192086e-08 3.30744594e-07
+ Co=
+ 1.03809111e-10
+ -4.53068653e-12 1.03809111e-10
+ Ro=
+ 3.96831067e+00
+ 0.00000000e+00 3.96831067e+00
+ Go=
+ 0.00000000e+00
+ -0.00000000e+00 0.00000000e+00
+ Rs=
+ 1.55902417e-03
+ -0.00000000e+00 1.55902417e-03
+ Gd=
+ 2.03826904e-11
+ -1.76114025e-13 2.03826904e-11

.Model Wmodel_Trace2693::MIPI_DSI0_DATA1_P W MODELTYPE=RLGC N=1
+ Lo=
+ 3.32029740e-07
+ Co=
+ 1.03489020e-10
+ Ro=
+ 3.96831067e+00
+ Go=
+ 0.00000000e+00
+ Rs=
+ 1.55902417e-03
+ Gd=
+ 2.04067990e-11

.Model Wmodel_Trace2695::MIPI_DSI0_DATA1_P W MODELTYPE=RLGC N=6
+ Lo=
+ 3.30692464e-07
+ 4.12577356e-08 3.29203485e-07
+ 1.22108988e-08 4.45369391e-08 3.29106880e-07
+ 5.27156237e-09 1.22179515e-08 4.15381133e-08 3.29545269e-07
+ 2.83242277e-09 5.08557223e-09 1.11521989e-08 3.83773194e-08 3.29620389e-07
+ 1.81844473e-09 2.84489044e-09 4.99007269e-09 1.12605123e-08 4.18815207e-08 3.30667557e-07
+ Co=
+ 1.03802239e-10
+ -4.38393854e-12 1.04190148e-10
+ -5.36277703e-13 -4.96338074e-12 1.04206715e-10
+ -2.27940654e-13 -5.26573536e-13 -4.44325856e-12 1.04064187e-10
+ -1.24396276e-13 -2.13825592e-13 -4.90308139e-13 -3.91745461e-12 1.04059133e-10
+ -8.26264132e-14 -1.22651335e-13 -2.14817998e-13 -5.06496363e-13 -4.48623006e-12 1.03814057e-10
+ Ro=
+ 3.96831067e+00
+ 0.00000000e+00 3.96831067e+00
+ 0.00000000e+00 0.00000000e+00 3.96831067e+00
+ 0.00000000e+00 0.00000000e+00 0.00000000e+00 3.96831067e+00
+ 0.00000000e+00 0.00000000e+00 0.00000000e+00 0.00000000e+00 3.96831067e+00
+ 0.00000000e+00 0.00000000e+00 0.00000000e+00 0.00000000e+00 0.00000000e+00 3.96831067e+00
+ Go=
+ 0.00000000e+00
+ -0.00000000e+00 0.00000000e+00
+ -0.00000000e+00 -0.00000000e+00 0.00000000e+00
+ -0.00000000e+00 -0.00000000e+00 -0.00000000e+00 0.00000000e+00
+ -0.00000000e+00 -0.00000000e+00 -0.00000000e+00 -0.00000000e+00 0.00000000e+00
+ -0.00000000e+00 -0.00000000e+00 -0.00000000e+00 -0.00000000e+00 -0.00000000e+00 0.00000000e+00
+ Rs=
+ 1.55902417e-03
+ -0.00000000e+00 1.55902417e-03
+ -0.00000000e+00 -0.00000000e+00 1.55902417e-03
+ -0.00000000e+00 -0.00000000e+00 -0.00000000e+00 1.55902417e-03
+ -0.00000000e+00 -0.00000000e+00 -0.00000000e+00 -0.00000000e+00 1.55902417e-03
+ -0.00000000e+00 -0.00000000e+00 -0.00000000e+00 -0.00000000e+00 -0.00000000e+00 1.55902417e-03
+ Gd=
+ 2.03821373e-11
+ -1.71094045e-13 2.03578590e-11
+ -0.00000000e+00 -2.37816563e-13 2.03570068e-11
+ -0.00000000e+00 -0.00000000e+00 -1.84126226e-13 2.03604244e-11
+ -0.00000000e+00 -0.00000000e+00 -0.00000000e+00 -1.32528259e-13 2.03610584e-11
+ -0.00000000e+00 -0.00000000e+00 -0.00000000e+00 -0.00000000e+00 -1.79463125e-13 2.03818755e-11

.Model Wmodel_Trace2696::MIPI_DSI0_DATA1_P W MODELTYPE=RLGC N=2
+ Lo=
+ 3.31623945e-07
+ 2.57991533e-08 3.31623945e-07
+ Co=
+ 1.03563508e-10
+ -2.13804211e-12 1.03563508e-10
+ Ro=
+ 3.96831067e+00
+ 0.00000000e+00 3.96831067e+00
+ Go=
+ 0.00000000e+00
+ -0.00000000e+00 0.00000000e+00
+ Rs=
+ 1.55902417e-03
+ -0.00000000e+00 1.55902417e-03
+ Gd=
+ 2.03963423e-11
+ -0.00000000e+00 2.03963423e-11

.Model Wmodel_Trace2697::MIPI_DSI0_DATA1_P W MODELTYPE=RLGC N=2
+ Lo=
+ 3.31647980e-07
+ 2.51256185e-08 3.31647980e-07
+ Co=
+ 1.03558177e-10
+ -2.05751966e-12 1.03558177e-10
+ Ro=
+ 3.96831067e+00
+ 0.00000000e+00 3.96831067e+00
+ Go=
+ 0.00000000e+00
+ -0.00000000e+00 0.00000000e+00
+ Rs=
+ 1.55902417e-03
+ -0.00000000e+00 1.55902417e-03
+ Gd=
+ 2.03969043e-11
+ -0.00000000e+00 2.03969043e-11

.Model Wmodel_Trace2698::MIPI_DSI0_DATA1_P W MODELTYPE=RLGC N=1
+ Lo=
+ 3.32029740e-07
+ Co=
+ 1.03489020e-10
+ Ro=
+ 3.96831067e+00
+ Go=
+ 0.00000000e+00
+ Rs=
+ 1.55902417e-03
+ Gd=
+ 2.04067990e-11

.Model Wmodel_Trace2699::MIPI_DSI0_DATA1_P W MODELTYPE=RLGC N=1
+ Lo=
+ 3.32029740e-07
+ Co=
+ 1.03489020e-10
+ Ro=
+ 3.96831067e+00
+ Go=
+ 0.00000000e+00
+ Rs=
+ 1.55902417e-03
+ Gd=
+ 2.04067990e-11

.Model Wmodel_Trace2699_Auto_1403::MIPI_DSI0_DATA1_P W MODELTYPE=RLGC N=2
+ Lo=
+ 3.30741760e-07
+ 4.22584810e-08 3.30741760e-07
+ Co=
+ 1.03810030e-10
+ -4.53734465e-12 1.03810030e-10
+ Ro=
+ 3.96831067e+00
+ 0.00000000e+00 3.96831067e+00
+ Go=
+ 0.00000000e+00
+ -0.00000000e+00 0.00000000e+00
+ Rs=
+ 1.55902417e-03
+ -0.00000000e+00 1.55902417e-03
+ Gd=
+ 2.03826671e-11
+ -1.76783050e-13 2.03826671e-11

.Model Wmodel_Trace2699_Auto_1404::MIPI_DSI0_DATA1_P W MODELTYPE=RLGC N=1
+ Lo=
+ 3.32029740e-07
+ Co=
+ 1.03489020e-10
+ Ro=
+ 3.96831067e+00
+ Go=
+ 0.00000000e+00
+ Rs=
+ 1.55902417e-03
+ Gd=
+ 2.04067990e-11

.Model Wmodel_Trace2701::MIPI_DSI0_DATA1_P W MODELTYPE=RLGC N=1
+ Lo=
+ 3.32029740e-07
+ Co=
+ 1.03489020e-10
+ Ro=
+ 3.96831067e+00
+ Go=
+ 0.00000000e+00
+ Rs=
+ 1.55902417e-03
+ Gd=
+ 2.04067990e-11

.Model Wmodel_Trace2701_Auto_1387::MIPI_DSI0_DATA1_P W MODELTYPE=RLGC N=2
+ Lo=
+ 3.30747962e-07
+ 4.21724824e-08 3.30747962e-07
+ Co=
+ 1.03808020e-10
+ -4.52277021e-12 1.03808020e-10
+ Ro=
+ 3.96831067e+00
+ 0.00000000e+00 3.96831067e+00
+ Go=
+ 0.00000000e+00
+ -0.00000000e+00 0.00000000e+00
+ Rs=
+ 1.55902417e-03
+ -0.00000000e+00 1.55902417e-03
+ Gd=
+ 2.03827182e-11
+ -1.75319307e-13 2.03827182e-11

.Model Wmodel_Trace2702::MIPI_DSI0_DATA1_P W MODELTYPE=RLGC N=1
+ Lo=
+ 3.32029740e-07
+ Co=
+ 1.03489020e-10
+ Ro=
+ 3.96831067e+00
+ Go=
+ 0.00000000e+00
+ Rs=
+ 1.55902417e-03
+ Gd=
+ 2.04067990e-11

.Model Wmodel_Trace2705::MIPI_DSI0_DATA1_P W MODELTYPE=RLGC N=1
+ Lo=
+ 3.32029740e-07
+ Co=
+ 1.03489020e-10
+ Ro=
+ 3.96831067e+00
+ Go=
+ 0.00000000e+00
+ Rs=
+ 1.55902417e-03
+ Gd=
+ 2.04067990e-11

.Model Wmodel_Trace2705_Auto_1390::MIPI_DSI0_DATA1_P W MODELTYPE=RLGC N=1
+ Lo=
+ 3.32029740e-07
+ Co=
+ 1.03489020e-10
+ Ro=
+ 3.96831067e+00
+ Go=
+ 0.00000000e+00
+ Rs=
+ 1.55902417e-03
+ Gd=
+ 2.04067990e-11

.Model Wmodel_Trace2706::MIPI_DSI0_DATA1_P W MODELTYPE=RLGC N=1
+ Lo=
+ 3.32029740e-07
+ Co=
+ 1.03489020e-10
+ Ro=
+ 3.96831067e+00
+ Go=
+ 0.00000000e+00
+ Rs=
+ 1.55902417e-03
+ Gd=
+ 2.04067990e-11

.Model Wmodel_Trace2706_Auto_1395::MIPI_DSI0_DATA1_P W MODELTYPE=RLGC N=2
+ Lo=
+ 3.30748712e-07
+ 4.21620598e-08 3.30748712e-07
+ Co=
+ 1.03807777e-10
+ -4.52100524e-12 1.03807777e-10
+ Ro=
+ 3.96831067e+00
+ 0.00000000e+00 3.96831067e+00
+ Go=
+ 0.00000000e+00
+ -0.00000000e+00 0.00000000e+00
+ Rs=
+ 1.55902417e-03
+ -0.00000000e+00 1.55902417e-03
+ Gd=
+ 2.03827244e-11
+ -1.75142230e-13 2.03827244e-11

.Model Wmodel_Trace2709#BP0_Auto_1398::MIPI_DSI0_DATA1_P W MODELTYPE=RLGC N=2
+ Lo=
+ 3.30686369e-07
+ 4.30157842e-08 3.30686369e-07
+ Co=
+ 1.03828115e-10
+ -4.66655610e-12 1.03828115e-10
+ Ro=
+ 3.96831067e+00
+ 0.00000000e+00 3.96831067e+00
+ Go=
+ 0.00000000e+00
+ -0.00000000e+00 0.00000000e+00
+ Rs=
+ 1.55902417e-03
+ -0.00000000e+00 1.55902417e-03
+ Gd=
+ 2.03822365e-11
+ -1.89876355e-13 2.03822365e-11

.Model Wmodel_Trace2711::MIPI_DSI0_DATA1_P W MODELTYPE=RLGC N=1
+ Lo=
+ 3.32029740e-07
+ Co=
+ 1.03489020e-10
+ Ro=
+ 3.96831067e+00
+ Go=
+ 0.00000000e+00
+ Rs=
+ 1.55902417e-03
+ Gd=
+ 2.04067990e-11

.Model Wmodel_Trace2713::MIPI_DSI0_DATA1_P W MODELTYPE=RLGC N=2
+ Lo=
+ 3.30740685e-07
+ 4.22733596e-08 3.30740685e-07
+ Co=
+ 1.03810378e-10
+ -4.53986822e-12 1.03810378e-10
+ Ro=
+ 3.96831067e+00
+ 0.00000000e+00 3.96831067e+00
+ Go=
+ 0.00000000e+00
+ -0.00000000e+00 0.00000000e+00
+ Rs=
+ 1.55902417e-03
+ -0.00000000e+00 1.55902417e-03
+ Gd=
+ 2.03826583e-11
+ -1.77036772e-13 2.03826583e-11

.Model Wmodel_Trace2715::MIPI_DSI0_DATA1_P W MODELTYPE=RLGC N=1
+ Lo=
+ 3.32029740e-07
+ Co=
+ 1.03489020e-10
+ Ro=
+ 3.96831067e+00
+ Go=
+ 0.00000000e+00
+ Rs=
+ 1.55902417e-03
+ Gd=
+ 2.04067990e-11

.Model Wmodel_Trace2717::MIPI_DSI0_DATA1_P W MODELTYPE=RLGC N=1
+ Lo=
+ 3.32029740e-07
+ Co=
+ 1.03489020e-10
+ Ro=
+ 3.96831067e+00
+ Go=
+ 0.00000000e+00
+ Rs=
+ 1.55902417e-03
+ Gd=
+ 2.04067990e-11

.Model Wmodel_Trace2717_Auto_1525::MIPI_DSI0_DATA1_P W MODELTYPE=RLGC N=2
+ Lo=
+ 3.30706127e-07
+ 4.27478337e-08 3.30706127e-07
+ Co=
+ 1.03821635e-10
+ -4.62066020e-12 1.03821635e-10
+ Ro=
+ 3.96831067e+00
+ 0.00000000e+00 3.96831067e+00
+ Go=
+ 0.00000000e+00
+ -0.00000000e+00 0.00000000e+00
+ Rs=
+ 1.55902417e-03
+ -0.00000000e+00 1.55902417e-03
+ Gd=
+ 2.03823848e-11
+ -1.85201950e-13 2.03823848e-11

.Model Wmodel_Trace2717_Auto_1526::MIPI_DSI0_DATA1_P W MODELTYPE=RLGC N=1
+ Lo=
+ 3.32029740e-07
+ Co=
+ 1.03489020e-10
+ Ro=
+ 3.96831067e+00
+ Go=
+ 0.00000000e+00
+ Rs=
+ 1.55902417e-03
+ Gd=
+ 2.04067990e-11

.Model Wmodel_Trace2719::MIPI_DSI0_DATA1_P W MODELTYPE=RLGC N=1
+ Lo=
+ 3.32029740e-07
+ Co=
+ 1.03489020e-10
+ Ro=
+ 3.96831067e+00
+ Go=
+ 0.00000000e+00
+ Rs=
+ 1.55902417e-03
+ Gd=
+ 2.04067990e-11

.Model Wmodel_Trace2721#BP0::MIPI_DSI0_DATA1_P W MODELTYPE=RLGC N=1
+ Lo=
+ 3.32029740e-07
+ Co=
+ 1.03489020e-10
+ Ro=
+ 3.96831067e+00
+ Go=
+ 0.00000000e+00
+ Rs=
+ 1.55902417e-03
+ Gd=
+ 2.04067990e-11

.Model Wmodel_Trace2721::MIPI_DSI0_DATA1_P W MODELTYPE=RLGC N=1
+ Lo=
+ 3.32029740e-07
+ Co=
+ 1.03489020e-10
+ Ro=
+ 3.96831067e+00
+ Go=
+ 0.00000000e+00
+ Rs=
+ 1.55902417e-03
+ Gd=
+ 2.04067990e-11

.Model Wmodel_Trace2721_Auto_1520::MIPI_DSI0_DATA1_P W MODELTYPE=RLGC N=2
+ Lo=
+ 3.30972072e-07
+ 3.88808126e-08 3.30972072e-07
+ Co=
+ 1.03737680e-10
+ -3.98027540e-12 1.03737680e-10
+ Ro=
+ 3.96831067e+00
+ 0.00000000e+00 3.96831067e+00
+ Go=
+ 0.00000000e+00
+ -0.00000000e+00 0.00000000e+00
+ Rs=
+ 1.55902417e-03
+ -0.00000000e+00 1.55902417e-03
+ Gd=
+ 2.03849704e-11
+ -1.22893168e-13 2.03849704e-11

.Model Wmodel_Trace2721_Auto_1521::MIPI_DSI0_DATA1_P W MODELTYPE=RLGC N=1
+ Lo=
+ 3.32029740e-07
+ Co=
+ 1.03489020e-10
+ Ro=
+ 3.96831067e+00
+ Go=
+ 0.00000000e+00
+ Rs=
+ 1.55902417e-03
+ Gd=
+ 2.04067990e-11

.Model Wmodel_Trace2721_Auto_1522::MIPI_DSI0_DATA1_P W MODELTYPE=RLGC N=2
+ Lo=
+ 3.30739001e-07
+ 4.22966526e-08 3.30739001e-07
+ Co=
+ 1.03810924e-10
+ -4.54382017e-12 1.03810924e-10
+ Ro=
+ 3.96831067e+00
+ 0.00000000e+00 3.96831067e+00
+ Go=
+ 0.00000000e+00
+ -0.00000000e+00 0.00000000e+00
+ Rs=
+ 1.55902417e-03
+ -0.00000000e+00 1.55902417e-03
+ Gd=
+ 2.03826445e-11
+ -1.77434267e-13 2.03826445e-11

.Model Wmodel_Trace2726::MIPI_DSI0_DATA1_P W MODELTYPE=RLGC N=1
+ Lo=
+ 3.32029740e-07
+ Co=
+ 1.03489020e-10
+ Ro=
+ 3.96831067e+00
+ Go=
+ 0.00000000e+00
+ Rs=
+ 1.55902417e-03
+ Gd=
+ 2.04067990e-11

.Model Wmodel_Trace2728#BP0::MIPI_DSI0_DATA1_P W MODELTYPE=RLGC N=1
+ Lo=
+ 3.32029740e-07
+ Co=
+ 1.03489020e-10
+ Ro=
+ 3.96831067e+00
+ Go=
+ 0.00000000e+00
+ Rs=
+ 1.55902417e-03
+ Gd=
+ 2.04067990e-11

.Model Wmodel_Trace2728#BP0_Auto_74::MIPI_DSI0_DATA1_P W MODELTYPE=RLGC N=2
+ Lo=
+ 3.30714095e-07
+ 4.26390948e-08 3.30714095e-07
+ Co=
+ 1.03819031e-10
+ -4.60209039e-12 1.03819031e-10
+ Ro=
+ 3.96831067e+00
+ 0.00000000e+00 3.96831067e+00
+ Go=
+ 0.00000000e+00
+ -0.00000000e+00 0.00000000e+00
+ Rs=
+ 1.55902417e-03
+ -0.00000000e+00 1.55902417e-03
+ Gd=
+ 2.03824462e-11
+ -1.83318004e-13 2.03824462e-11

.Model Wmodel_Trace2728#BP0_Auto_76::MIPI_DSI0_DATA1_P W MODELTYPE=RLGC N=1
+ Lo=
+ 3.32029740e-07
+ Co=
+ 1.03489020e-10
+ Ro=
+ 3.96831067e+00
+ Go=
+ 0.00000000e+00
+ Rs=
+ 1.55902417e-03
+ Gd=
+ 2.04067990e-11

.Model Wmodel_Trace2730::MIPI_DSI0_DATA1_P W MODELTYPE=RLGC N=1
+ Lo=
+ 3.32029740e-07
+ Co=
+ 1.03489020e-10
+ Ro=
+ 3.96831067e+00
+ Go=
+ 0.00000000e+00
+ Rs=
+ 1.55902417e-03
+ Gd=
+ 2.04067990e-11

.Model Wmodel_Trace2732::MIPI_DSI0_DATA1_P W MODELTYPE=RLGC N=1
+ Lo=
+ 3.32029740e-07
+ Co=
+ 1.03489020e-10
+ Ro=
+ 3.96831067e+00
+ Go=
+ 0.00000000e+00
+ Rs=
+ 1.55902417e-03
+ Gd=
+ 2.04067990e-11

.Model Wmodel_Trace2732_Auto_73::MIPI_DSI0_DATA1_P W MODELTYPE=RLGC N=2
+ Lo=
+ 3.30740391e-07
+ 4.22774243e-08 3.30740391e-07
+ Co=
+ 1.03810473e-10
+ -4.54055774e-12 1.03810473e-10
+ Ro=
+ 3.96831067e+00
+ 0.00000000e+00 3.96831067e+00
+ Go=
+ 0.00000000e+00
+ -0.00000000e+00 0.00000000e+00
+ Rs=
+ 1.55902417e-03
+ -0.00000000e+00 1.55902417e-03
+ Gd=
+ 2.03826559e-11
+ -1.77106111e-13 2.03826559e-11

.Model Wmodel_Trace2733::MIPI_DSI0_DATA1_P W MODELTYPE=RLGC N=1
+ Lo=
+ 3.32029740e-07
+ Co=
+ 1.03489020e-10
+ Ro=
+ 3.96831067e+00
+ Go=
+ 0.00000000e+00
+ Rs=
+ 1.55902417e-03
+ Gd=
+ 2.04067990e-11

.Model Wmodel_Trace2738_Auto_100::MIPI_DSI0_DATA1_P W MODELTYPE=RLGC N=1
+ Lo=
+ 3.32029740e-07
+ Co=
+ 1.03489020e-10
+ Ro=
+ 3.96831067e+00
+ Go=
+ 0.00000000e+00
+ Rs=
+ 1.55902417e-03
+ Gd=
+ 2.04067990e-11

.Model Wmodel_Trace2747::MIPI_DSI0_DATA1_P W MODELTYPE=RLGC N=1
+ Lo=
+ 3.32029740e-07
+ Co=
+ 1.03489020e-10
+ Ro=
+ 3.96831067e+00
+ Go=
+ 0.00000000e+00
+ Rs=
+ 1.55902417e-03
+ Gd=
+ 2.04067990e-11

.Model Wmodel_Trace2749::MIPI_DSI0_DATA1_P W MODELTYPE=RLGC N=1
+ Lo=
+ 3.32029740e-07
+ Co=
+ 1.03489020e-10
+ Ro=
+ 3.96831067e+00
+ Go=
+ 0.00000000e+00
+ Rs=
+ 1.55902417e-03
+ Gd=
+ 2.04067990e-11

.Model Wmodel_Trace2751::MIPI_DSI0_DATA1_P W MODELTYPE=RLGC N=1
+ Lo=
+ 3.32029740e-07
+ Co=
+ 1.03489020e-10
+ Ro=
+ 3.96831067e+00
+ Go=
+ 0.00000000e+00
+ Rs=
+ 1.55902417e-03
+ Gd=
+ 2.04067990e-11

.Model Wmodel_Trace2753::MIPI_DSI0_DATA1_P W MODELTYPE=RLGC N=1
+ Lo=
+ 3.32029740e-07
+ Co=
+ 1.03489020e-10
+ Ro=
+ 3.96831067e+00
+ Go=
+ 0.00000000e+00
+ Rs=
+ 1.55902417e-03
+ Gd=
+ 2.04067990e-11

.Model Wmodel_Trace2755::MIPI_DSI0_DATA1_P W MODELTYPE=RLGC N=1
+ Lo=
+ 3.32029740e-07
+ Co=
+ 1.03489020e-10
+ Ro=
+ 3.96831067e+00
+ Go=
+ 0.00000000e+00
+ Rs=
+ 1.55902417e-03
+ Gd=
+ 2.04067990e-11

.Model Wmodel_Trace2755_Auto_244::MIPI_DSI0_DATA1_P W MODELTYPE=RLGC N=2
+ Lo=
+ 3.30680401e-07
+ 4.30962469e-08 3.30680401e-07
+ Co=
+ 1.03830079e-10
+ -4.68037612e-12 1.03830079e-10
+ Ro=
+ 3.96831067e+00
+ 0.00000000e+00 3.96831067e+00
+ Go=
+ 0.00000000e+00
+ -0.00000000e+00 0.00000000e+00
+ Rs=
+ 1.55902417e-03
+ -0.00000000e+00 1.55902417e-03
+ Gd=
+ 2.03821929e-11
+ -1.91288918e-13 2.03821929e-11

.Model Wmodel_Trace2757::MIPI_DSI0_DATA1_P W MODELTYPE=RLGC N=1
+ Lo=
+ 3.32029740e-07
+ Co=
+ 1.03489020e-10
+ Ro=
+ 3.96831067e+00
+ Go=
+ 0.00000000e+00
+ Rs=
+ 1.55902417e-03
+ Gd=
+ 2.04067990e-11

.Model Wmodel_Trace2759::MIPI_DSI0_DATA1_P W MODELTYPE=RLGC N=1
+ Lo=
+ 3.32029740e-07
+ Co=
+ 1.03489020e-10
+ Ro=
+ 3.96831067e+00
+ Go=
+ 0.00000000e+00
+ Rs=
+ 1.55902417e-03
+ Gd=
+ 2.04067990e-11

.Model Wmodel_Trace2763::MIPI_DSI0_DATA1_P W MODELTYPE=RLGC N=1
+ Lo=
+ 3.32029740e-07
+ Co=
+ 1.03489020e-10
+ Ro=
+ 3.96831067e+00
+ Go=
+ 0.00000000e+00
+ Rs=
+ 1.55902417e-03
+ Gd=
+ 2.04067990e-11

.Model Wmodel_Trace2764::MIPI_DSI0_DATA1_P W MODELTYPE=RLGC N=1
+ Lo=
+ 3.32029740e-07
+ Co=
+ 1.03489020e-10
+ Ro=
+ 3.96831067e+00
+ Go=
+ 0.00000000e+00
+ Rs=
+ 1.55902417e-03
+ Gd=
+ 2.04067990e-11

.Model Wmodel_Trace2767::MIPI_DSI0_DATA1_P W MODELTYPE=RLGC N=1
+ Lo=
+ 3.58484574e-07
+ Co=
+ 9.37055974e-11
+ Ro=
+ 4.84133902e+00
+ Go=
+ 0.00000000e+00
+ Rs=
+ 1.72420198e-03
+ Gd=
+ 1.82370500e-11

.Model Wmodel_Trace2768::MIPI_DSI0_DATA1_P W MODELTYPE=RLGC N=1
+ Lo=
+ 3.58484574e-07
+ Co=
+ 9.37055974e-11
+ Ro=
+ 4.84133902e+00
+ Go=
+ 0.00000000e+00
+ Rs=
+ 1.72420198e-03
+ Gd=
+ 1.82370500e-11

.Model Wmodel_Trace2768_Auto_1024::MIPI_DSI0_DATA1_P W MODELTYPE=RLGC N=1
+ Lo=
+ 3.58484574e-07
+ Co=
+ 9.37055974e-11
+ Ro=
+ 4.84133902e+00
+ Go=
+ 0.00000000e+00
+ Rs=
+ 1.72420198e-03
+ Gd=
+ 1.82370500e-11

.Model Wmodel_Trace2770::MIPI_DSI0_DATA1_P W MODELTYPE=RLGC N=1
+ Lo=
+ 3.58484574e-07
+ Co=
+ 9.37055974e-11
+ Ro=
+ 4.84133902e+00
+ Go=
+ 0.00000000e+00
+ Rs=
+ 1.72420198e-03
+ Gd=
+ 1.82370500e-11

.Model Wmodel_Trace3059::MIPI_DSI0_DATA0_P W MODELTYPE=RLGC N=1
+ Lo=
+ 3.32029740e-07
+ Co=
+ 1.03489020e-10
+ Ro=
+ 3.96831067e+00
+ Go=
+ 0.00000000e+00
+ Rs=
+ 1.55902417e-03
+ Gd=
+ 2.04067990e-11

.Model Wmodel_Trace3062::MIPI_DSI0_DATA0_P W MODELTYPE=RLGC N=1
+ Lo=
+ 3.32029740e-07
+ Co=
+ 1.03489020e-10
+ Ro=
+ 3.96831067e+00
+ Go=
+ 0.00000000e+00
+ Rs=
+ 1.55902417e-03
+ Gd=
+ 2.04067990e-11

.Model Wmodel_Trace3063_Auto_1597::MIPI_DSI0_DATA0_P W MODELTYPE=RLGC N=2
+ Lo=
+ 3.30715126e-07
+ 4.26249921e-08 3.30715126e-07
+ Co=
+ 1.03818694e-10
+ -4.59968437e-12 1.03818694e-10
+ Ro=
+ 3.96831067e+00
+ 0.00000000e+00 3.96831067e+00
+ Go=
+ 0.00000000e+00
+ -0.00000000e+00 0.00000000e+00
+ Rs=
+ 1.55902417e-03
+ -0.00000000e+00 1.55902417e-03
+ Gd=
+ 2.03824542e-11
+ -1.83074221e-13 2.03824542e-11

.Model Wmodel_Trace3065::MIPI_DSI0_DATA0_P W MODELTYPE=RLGC N=1
+ Lo=
+ 3.32029740e-07
+ Co=
+ 1.03489020e-10
+ Ro=
+ 3.96831067e+00
+ Go=
+ 0.00000000e+00
+ Rs=
+ 1.55902417e-03
+ Gd=
+ 2.04067990e-11

.Model Wmodel_Trace3067::MIPI_DSI0_DATA0_P W MODELTYPE=RLGC N=2
+ Lo=
+ 3.30748904e-07
+ 4.21593990e-08 3.30748904e-07
+ Co=
+ 1.03807716e-10
+ -4.52055469e-12 1.03807716e-10
+ Ro=
+ 3.96831067e+00
+ 0.00000000e+00 3.96831067e+00
+ Go=
+ 0.00000000e+00
+ -0.00000000e+00 0.00000000e+00
+ Rs=
+ 1.55902417e-03
+ -0.00000000e+00 1.55902417e-03
+ Gd=
+ 2.03827260e-11
+ -1.75097034e-13 2.03827260e-11

.Model Wmodel_Trace3072::MIPI_DSI0_DATA0_P W MODELTYPE=RLGC N=1
+ Lo=
+ 3.32029740e-07
+ Co=
+ 1.03489020e-10
+ Ro=
+ 3.96831067e+00
+ Go=
+ 0.00000000e+00
+ Rs=
+ 1.55902417e-03
+ Gd=
+ 2.04067990e-11

.Model Wmodel_Trace3077::MIPI_DSI0_DATA0_P W MODELTYPE=RLGC N=1
+ Lo=
+ 3.32029740e-07
+ Co=
+ 1.03489020e-10
+ Ro=
+ 3.96831067e+00
+ Go=
+ 0.00000000e+00
+ Rs=
+ 1.55902417e-03
+ Gd=
+ 2.04067990e-11

.Model Wmodel_Trace3084::MIPI_DSI0_DATA0_P W MODELTYPE=RLGC N=1
+ Lo=
+ 3.32029740e-07
+ Co=
+ 1.03489020e-10
+ Ro=
+ 3.96831067e+00
+ Go=
+ 0.00000000e+00
+ Rs=
+ 1.55902417e-03
+ Gd=
+ 2.04067990e-11

.Model Wmodel_Trace3089::MIPI_DSI0_DATA0_P W MODELTYPE=RLGC N=1
+ Lo=
+ 3.32029740e-07
+ Co=
+ 1.03489020e-10
+ Ro=
+ 3.96831067e+00
+ Go=
+ 0.00000000e+00
+ Rs=
+ 1.55902417e-03
+ Gd=
+ 2.04067990e-11

.Model Wmodel_Trace3091::MIPI_DSI0_DATA0_P W MODELTYPE=RLGC N=1
+ Lo=
+ 3.32029740e-07
+ Co=
+ 1.03489020e-10
+ Ro=
+ 3.96831067e+00
+ Go=
+ 0.00000000e+00
+ Rs=
+ 1.55902417e-03
+ Gd=
+ 2.04067990e-11

.Model Wmodel_Trace3091_Auto_1601::MIPI_DSI0_DATA0_P W MODELTYPE=RLGC N=2
+ Lo=
+ 3.30714981e-07
+ 4.26269733e-08 3.30714981e-07
+ Co=
+ 1.03818741e-10
+ -4.60002234e-12 1.03818741e-10
+ Ro=
+ 3.96831067e+00
+ 0.00000000e+00 3.96831067e+00
+ Go=
+ 0.00000000e+00
+ -0.00000000e+00 0.00000000e+00
+ Rs=
+ 1.55902417e-03
+ -0.00000000e+00 1.55902417e-03
+ Gd=
+ 2.03824531e-11
+ -1.83108461e-13 2.03824531e-11

.Model Wmodel_Trace3091_Auto_1603::MIPI_DSI0_DATA0_P W MODELTYPE=RLGC N=1
+ Lo=
+ 3.32029740e-07
+ Co=
+ 1.03489020e-10
+ Ro=
+ 3.96831067e+00
+ Go=
+ 0.00000000e+00
+ Rs=
+ 1.55902417e-03
+ Gd=
+ 2.04067990e-11

.Model Wmodel_Trace3095::MIPI_DSI0_DATA0_P W MODELTYPE=RLGC N=1
+ Lo=
+ 3.32029740e-07
+ Co=
+ 1.03489020e-10
+ Ro=
+ 3.96831067e+00
+ Go=
+ 0.00000000e+00
+ Rs=
+ 1.55902417e-03
+ Gd=
+ 2.04067990e-11

.Model Wmodel_Trace3096::MIPI_DSI0_DATA0_P W MODELTYPE=RLGC N=1
+ Lo=
+ 3.32029740e-07
+ Co=
+ 1.03489020e-10
+ Ro=
+ 3.96831067e+00
+ Go=
+ 0.00000000e+00
+ Rs=
+ 1.55902417e-03
+ Gd=
+ 2.04067990e-11

.Model Wmodel_Trace3096_Auto_1859::MIPI_DSI0_DATA0_P W MODELTYPE=RLGC N=2
+ Lo=
+ 3.30679902e-07
+ 4.31029668e-08 3.30679902e-07
+ Co=
+ 1.03830243e-10
+ -4.68153109e-12 1.03830243e-10
+ Ro=
+ 3.96831067e+00
+ 0.00000000e+00 3.96831067e+00
+ Go=
+ 0.00000000e+00
+ -0.00000000e+00 0.00000000e+00
+ Rs=
+ 1.55902417e-03
+ -0.00000000e+00 1.55902417e-03
+ Gd=
+ 2.03821893e-11
+ -1.91407074e-13 2.03821893e-11

.Model Wmodel_Trace3106::MIPI_DSI0_DATA0_P W MODELTYPE=RLGC N=1
+ Lo=
+ 3.32029740e-07
+ Co=
+ 1.03489020e-10
+ Ro=
+ 3.96831067e+00
+ Go=
+ 0.00000000e+00
+ Rs=
+ 1.55902417e-03
+ Gd=
+ 2.04067990e-11

.Model Wmodel_Trace3109::MIPI_DSI0_DATA0_P W MODELTYPE=RLGC N=1
+ Lo=
+ 3.32029740e-07
+ Co=
+ 1.03489020e-10
+ Ro=
+ 3.96831067e+00
+ Go=
+ 0.00000000e+00
+ Rs=
+ 1.55902417e-03
+ Gd=
+ 2.04067990e-11

.Model Wmodel_Trace3118::MIPI_DSI0_DATA0_P W MODELTYPE=RLGC N=1
+ Lo=
+ 3.32029740e-07
+ Co=
+ 1.03489020e-10
+ Ro=
+ 3.96831067e+00
+ Go=
+ 0.00000000e+00
+ Rs=
+ 1.55902417e-03
+ Gd=
+ 2.04067990e-11

.Model Wmodel_Trace3119::MIPI_DSI0_DATA0_P W MODELTYPE=RLGC N=1
+ Lo=
+ 3.32029740e-07
+ Co=
+ 1.03489020e-10
+ Ro=
+ 3.96831067e+00
+ Go=
+ 0.00000000e+00
+ Rs=
+ 1.55902417e-03
+ Gd=
+ 2.04067990e-11

.Model Wmodel_Trace3119_Auto_1857::MIPI_DSI0_DATA0_P W MODELTYPE=RLGC N=2
+ Lo=
+ 3.30679471e-07
+ 4.31087789e-08 3.30679471e-07
+ Co=
+ 1.03830385e-10
+ -4.68253014e-12 1.03830385e-10
+ Ro=
+ 3.96831067e+00
+ 0.00000000e+00 3.96831067e+00
+ Go=
+ 0.00000000e+00
+ -0.00000000e+00 0.00000000e+00
+ Rs=
+ 1.55902417e-03
+ -0.00000000e+00 1.55902417e-03
+ Gd=
+ 2.03821862e-11
+ -1.91509291e-13 2.03821862e-11

.Model Wmodel_Trace3129::MIPI_DSI0_DATA0_P W MODELTYPE=RLGC N=1
+ Lo=
+ 3.32029740e-07
+ Co=
+ 1.03489020e-10
+ Ro=
+ 3.96831067e+00
+ Go=
+ 0.00000000e+00
+ Rs=
+ 1.55902417e-03
+ Gd=
+ 2.04067990e-11

.Model Wmodel_Trace3131::MIPI_DSI0_DATA0_P W MODELTYPE=RLGC N=2
+ Lo=
+ 3.30680333e-07
+ 4.30971638e-08 3.30680333e-07
+ Co=
+ 1.03830101e-10
+ -4.68053370e-12 1.03830101e-10
+ Ro=
+ 3.96831067e+00
+ 0.00000000e+00 3.96831067e+00
+ Go=
+ 0.00000000e+00
+ -0.00000000e+00 0.00000000e+00
+ Rs=
+ 1.55902417e-03
+ -0.00000000e+00 1.55902417e-03
+ Gd=
+ 2.03821924e-11
+ -1.91305038e-13 2.03821924e-11

.Model Wmodel_Trace3131_Auto_1864::MIPI_DSI0_DATA0_P W MODELTYPE=RLGC N=1
+ Lo=
+ 3.32029740e-07
+ Co=
+ 1.03489020e-10
+ Ro=
+ 3.96831067e+00
+ Go=
+ 0.00000000e+00
+ Rs=
+ 1.55902417e-03
+ Gd=
+ 2.04067990e-11

.Model Wmodel_Trace3135::MIPI_DSI0_DATA0_P W MODELTYPE=RLGC N=1
+ Lo=
+ 3.32029740e-07
+ Co=
+ 1.03489020e-10
+ Ro=
+ 3.96831067e+00
+ Go=
+ 0.00000000e+00
+ Rs=
+ 1.55902417e-03
+ Gd=
+ 2.04067990e-11

.Model Wmodel_Trace3137::MIPI_DSI0_DATA0_P W MODELTYPE=RLGC N=1
+ Lo=
+ 3.32029740e-07
+ Co=
+ 1.03489020e-10
+ Ro=
+ 3.96831067e+00
+ Go=
+ 0.00000000e+00
+ Rs=
+ 1.55902417e-03
+ Gd=
+ 2.04067990e-11

.Model Wmodel_Trace3137_Auto_1905::MIPI_DSI0_DATA0_P W MODELTYPE=RLGC N=2
+ Lo=
+ 3.30748904e-07
+ 4.21593990e-08 3.30748904e-07
+ Co=
+ 1.03807716e-10
+ -4.52055469e-12 1.03807716e-10
+ Ro=
+ 3.96831067e+00
+ 0.00000000e+00 3.96831067e+00
+ Go=
+ 0.00000000e+00
+ -0.00000000e+00 0.00000000e+00
+ Rs=
+ 1.55902417e-03
+ -0.00000000e+00 1.55902417e-03
+ Gd=
+ 2.03827260e-11
+ -1.75097034e-13 2.03827260e-11

.Model Wmodel_Trace3138::MIPI_DSI0_DATA0_P W MODELTYPE=RLGC N=1
+ Lo=
+ 3.32029740e-07
+ Co=
+ 1.03489020e-10
+ Ro=
+ 3.96831067e+00
+ Go=
+ 0.00000000e+00
+ Rs=
+ 1.55902417e-03
+ Gd=
+ 2.04067990e-11

.Model Wmodel_Trace3139::MIPI_DSI0_DATA0_P W MODELTYPE=RLGC N=2
+ Lo=
+ 3.31084817e-07
+ 3.70655270e-08 3.31084817e-07
+ Co=
+ 1.03704070e-10
+ -3.69414683e-12 1.03704070e-10
+ Ro=
+ 3.96831067e+00
+ 0.00000000e+00 3.96831067e+00
+ Go=
+ 0.00000000e+00
+ -0.00000000e+00 0.00000000e+00
+ Rs=
+ 1.55902417e-03
+ -0.00000000e+00 1.55902417e-03
+ Gd=
+ 2.03864112e-11
+ -9.70380340e-14 2.03864112e-11

.Model Wmodel_Trace3139_Auto_1904::MIPI_DSI0_DATA0_P W MODELTYPE=RLGC N=1
+ Lo=
+ 3.32029740e-07
+ Co=
+ 1.03489020e-10
+ Ro=
+ 3.96831067e+00
+ Go=
+ 0.00000000e+00
+ Rs=
+ 1.55902417e-03
+ Gd=
+ 2.04067990e-11

.Model Wmodel_Trace3143::MIPI_DSI0_DATA0_P W MODELTYPE=RLGC N=1
+ Lo=
+ 3.32029740e-07
+ Co=
+ 1.03489020e-10
+ Ro=
+ 3.96831067e+00
+ Go=
+ 0.00000000e+00
+ Rs=
+ 1.55902417e-03
+ Gd=
+ 2.04067990e-11

.Model Wmodel_Trace3146::MIPI_DSI0_DATA0_P W MODELTYPE=RLGC N=1
+ Lo=
+ 3.32029740e-07
+ Co=
+ 1.03489020e-10
+ Ro=
+ 3.96831067e+00
+ Go=
+ 0.00000000e+00
+ Rs=
+ 1.55902417e-03
+ Gd=
+ 2.04067990e-11

.Model Wmodel_Trace3147_Auto_79::MIPI_DSI0_DATA0_P W MODELTYPE=RLGC N=1
+ Lo=
+ 3.32029740e-07
+ Co=
+ 1.03489020e-10
+ Ro=
+ 3.96831067e+00
+ Go=
+ 0.00000000e+00
+ Rs=
+ 1.55902417e-03
+ Gd=
+ 2.04067990e-11

.Model Wmodel_Trace3148::MIPI_DSI0_DATA0_P W MODELTYPE=RLGC N=1
+ Lo=
+ 3.32029740e-07
+ Co=
+ 1.03489020e-10
+ Ro=
+ 3.96831067e+00
+ Go=
+ 0.00000000e+00
+ Rs=
+ 1.55902417e-03
+ Gd=
+ 2.04067990e-11

.Model Wmodel_Trace3150::MIPI_DSI0_DATA0_P W MODELTYPE=RLGC N=2
+ Lo=
+ 3.30762906e-07
+ 4.19642357e-08 3.30762906e-07
+ Co=
+ 1.03803192e-10
+ -4.48756170e-12 1.03803192e-10
+ Ro=
+ 3.96831067e+00
+ 0.00000000e+00 3.96831067e+00
+ Go=
+ 0.00000000e+00
+ -0.00000000e+00 0.00000000e+00
+ Rs=
+ 1.55902417e-03
+ -0.00000000e+00 1.55902417e-03
+ Gd=
+ 2.03828438e-11
+ -1.71794447e-13 2.03828438e-11

.Model Wmodel_Trace3150_Auto_83::MIPI_DSI0_DATA0_P W MODELTYPE=RLGC N=1
+ Lo=
+ 3.32029740e-07
+ Co=
+ 1.03489020e-10
+ Ro=
+ 3.96831067e+00
+ Go=
+ 0.00000000e+00
+ Rs=
+ 1.55902417e-03
+ Gd=
+ 2.04067990e-11

.Model Wmodel_Trace3170::MIPI_DSI0_DATA0_P W MODELTYPE=RLGC N=1
+ Lo=
+ 3.32029740e-07
+ Co=
+ 1.03489020e-10
+ Ro=
+ 3.96831067e+00
+ Go=
+ 0.00000000e+00
+ Rs=
+ 1.55902417e-03
+ Gd=
+ 2.04067990e-11

.Model Wmodel_Trace3172::MIPI_DSI0_DATA0_P W MODELTYPE=RLGC N=1
+ Lo=
+ 3.32029740e-07
+ Co=
+ 1.03489020e-10
+ Ro=
+ 3.96831067e+00
+ Go=
+ 0.00000000e+00
+ Rs=
+ 1.55902417e-03
+ Gd=
+ 2.04067990e-11

.Model Wmodel_Trace3172_Auto_85::MIPI_DSI0_DATA0_P W MODELTYPE=RLGC N=1
+ Lo=
+ 3.32029740e-07
+ Co=
+ 1.03489020e-10
+ Ro=
+ 3.96831067e+00
+ Go=
+ 0.00000000e+00
+ Rs=
+ 1.55902417e-03
+ Gd=
+ 2.04067990e-11

.Model Wmodel_Trace3172_Auto_89::MIPI_DSI0_DATA0_P W MODELTYPE=RLGC N=2
+ Lo=
+ 3.30748301e-07
+ 4.21677645e-08 3.30748301e-07
+ Co=
+ 1.03807910e-10
+ -4.52197123e-12 1.03807910e-10
+ Ro=
+ 3.96831067e+00
+ 0.00000000e+00 3.96831067e+00
+ Go=
+ 0.00000000e+00
+ -0.00000000e+00 0.00000000e+00
+ Rs=
+ 1.55902417e-03
+ -0.00000000e+00 1.55902417e-03
+ Gd=
+ 2.03827210e-11
+ -1.75239142e-13 2.03827210e-11

.Model Wmodel_Trace3172_Auto_93::MIPI_DSI0_DATA0_P W MODELTYPE=RLGC N=1
+ Lo=
+ 3.32029740e-07
+ Co=
+ 1.03489020e-10
+ Ro=
+ 3.96831067e+00
+ Go=
+ 0.00000000e+00
+ Rs=
+ 1.55902417e-03
+ Gd=
+ 2.04067990e-11

.Model Wmodel_Trace3172_Auto_98::MIPI_DSI0_DATA0_P W MODELTYPE=RLGC N=2
+ Lo=
+ 3.30761768e-07
+ 4.19801474e-08 3.30761768e-07
+ Co=
+ 1.03803559e-10
+ -4.49024773e-12 1.03803559e-10
+ Ro=
+ 3.96831067e+00
+ 0.00000000e+00 3.96831067e+00
+ Go=
+ 0.00000000e+00
+ -0.00000000e+00 0.00000000e+00
+ Rs=
+ 1.55902417e-03
+ -0.00000000e+00 1.55902417e-03
+ Gd=
+ 2.03828341e-11
+ -1.72062794e-13 2.03828341e-11

.Model Wmodel_Trace3173::MIPI_DSI0_DATA0_P W MODELTYPE=RLGC N=2
+ Lo=
+ 3.30748904e-07
+ 4.21593990e-08 3.30748904e-07
+ Co=
+ 1.03807716e-10
+ -4.52055469e-12 1.03807716e-10
+ Ro=
+ 3.96831067e+00
+ 0.00000000e+00 3.96831067e+00
+ Go=
+ 0.00000000e+00
+ -0.00000000e+00 0.00000000e+00
+ Rs=
+ 1.55902417e-03
+ -0.00000000e+00 1.55902417e-03
+ Gd=
+ 2.03827260e-11
+ -1.75097034e-13 2.03827260e-11

.Model Wmodel_Trace3173_Auto_182::MIPI_DSI0_DATA0_P W MODELTYPE=RLGC N=1
+ Lo=
+ 3.32029740e-07
+ Co=
+ 1.03489020e-10
+ Ro=
+ 3.96831067e+00
+ Go=
+ 0.00000000e+00
+ Rs=
+ 1.55902417e-03
+ Gd=
+ 2.04067990e-11

.Model Wmodel_Trace3174::MIPI_DSI0_DATA0_P W MODELTYPE=RLGC N=1
+ Lo=
+ 3.32029740e-07
+ Co=
+ 1.03489020e-10
+ Ro=
+ 3.96831067e+00
+ Go=
+ 0.00000000e+00
+ Rs=
+ 1.55902417e-03
+ Gd=
+ 2.04067990e-11

.Model Wmodel_Trace3174_Auto_209::MIPI_DSI0_DATA0_P W MODELTYPE=RLGC N=3
+ Lo=
+ 3.29814497e-07
+ 5.17582915e-08 3.28651984e-07
+ 1.35352793e-08 4.17432748e-08 3.30652929e-07
+ Co=
+ 1.04111361e-10
+ -6.29169205e-12 1.04416214e-10
+ -5.87965586e-13 -4.46617187e-12 1.03814107e-10
+ Ro=
+ 3.96831067e+00
+ 0.00000000e+00 3.96831067e+00
+ 0.00000000e+00 0.00000000e+00 3.96831067e+00
+ Go=
+ 0.00000000e+00
+ -0.00000000e+00 0.00000000e+00
+ -0.00000000e+00 -0.00000000e+00 0.00000000e+00
+ Rs=
+ 1.55902417e-03
+ -0.00000000e+00 1.55902417e-03
+ -0.00000000e+00 -0.00000000e+00 1.55902417e-03
+ Gd=
+ 2.03799465e-11
+ -3.78691612e-13 2.03581635e-11
+ -0.00000000e+00 -1.80742591e-13 2.03819325e-11

.Model Wmodel_Trace3174_Auto_210::MIPI_DSI0_DATA0_P W MODELTYPE=RLGC N=1
+ Lo=
+ 3.32029740e-07
+ Co=
+ 1.03489020e-10
+ Ro=
+ 3.96831067e+00
+ Go=
+ 0.00000000e+00
+ Rs=
+ 1.55902417e-03
+ Gd=
+ 2.04067990e-11

.Model Wmodel_Trace3174_Auto_235::MIPI_DSI0_DATA0_P W MODELTYPE=RLGC N=2
+ Lo=
+ 3.30748548e-07
+ 4.21643423e-08 3.30748548e-07
+ Co=
+ 1.03807831e-10
+ -4.52139172e-12 1.03807831e-10
+ Ro=
+ 3.96831067e+00
+ 0.00000000e+00 3.96831067e+00
+ Go=
+ 0.00000000e+00
+ -0.00000000e+00 0.00000000e+00
+ Rs=
+ 1.55902417e-03
+ -0.00000000e+00 1.55902417e-03
+ Gd=
+ 2.03827231e-11
+ -1.75181003e-13 2.03827231e-11

.Model Wmodel_Trace3176::MIPI_DSI0_DATA0_P W MODELTYPE=RLGC N=1
+ Lo=
+ 3.32029740e-07
+ Co=
+ 1.03489020e-10
+ Ro=
+ 3.96831067e+00
+ Go=
+ 0.00000000e+00
+ Rs=
+ 1.55902417e-03
+ Gd=
+ 2.04067990e-11

.Model Wmodel_Trace3199::MIPI_DSI0_DATA0_P W MODELTYPE=RLGC N=1
+ Lo=
+ 3.32029740e-07
+ Co=
+ 1.03489020e-10
+ Ro=
+ 3.96831067e+00
+ Go=
+ 0.00000000e+00
+ Rs=
+ 1.55902417e-03
+ Gd=
+ 2.04067990e-11

.Model Wmodel_Trace3201_Auto_264::MIPI_DSI0_DATA0_P W MODELTYPE=RLGC N=1
+ Lo=
+ 3.32029740e-07
+ Co=
+ 1.03489020e-10
+ Ro=
+ 3.96831067e+00
+ Go=
+ 0.00000000e+00
+ Rs=
+ 1.55902417e-03
+ Gd=
+ 2.04067990e-11

.Model Wmodel_Trace3203::MIPI_DSI0_DATA0_P W MODELTYPE=RLGC N=1
+ Lo=
+ 3.58484574e-07
+ Co=
+ 9.37055974e-11
+ Ro=
+ 4.84133902e+00
+ Go=
+ 0.00000000e+00
+ Rs=
+ 1.72420198e-03
+ Gd=
+ 1.82370500e-11

.Model Wmodel_Trace3204::MIPI_DSI0_DATA0_P W MODELTYPE=RLGC N=1
+ Lo=
+ 3.58484574e-07
+ Co=
+ 9.37055974e-11
+ Ro=
+ 4.84133902e+00
+ Go=
+ 0.00000000e+00
+ Rs=
+ 1.72420198e-03
+ Gd=
+ 1.82370500e-11

.Model Wmodel_Trace3205::MIPI_DSI0_DATA0_P W MODELTYPE=RLGC N=1
+ Lo=
+ 3.58484574e-07
+ Co=
+ 9.37055974e-11
+ Ro=
+ 4.84133902e+00
+ Go=
+ 0.00000000e+00
+ Rs=
+ 1.72420198e-03
+ Gd=
+ 1.82370500e-11

.Model Wmodel_Trace3206_Auto_1028::MIPI_DSI0_DATA0_P W MODELTYPE=RLGC N=1
+ Lo=
+ 3.58484574e-07
+ Co=
+ 9.37055974e-11
+ Ro=
+ 4.84133902e+00
+ Go=
+ 0.00000000e+00
+ Rs=
+ 1.72420198e-03
+ Gd=
+ 1.82370500e-11
