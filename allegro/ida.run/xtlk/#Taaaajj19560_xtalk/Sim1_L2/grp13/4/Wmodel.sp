*Wmodel Definition*
*TraceModel Definition*

.Model Wmodel_Trace1001_Auto_1885::MIPI_DSI1_DATA2_N W MODELTYPE=RLGC N=1
+ Lo=
+ 3.32029740e-07
+ Co=
+ 1.03489020e-10
+ Ro=
+ 3.96831067e+00
+ Go=
+ 0.00000000e+00
+ Rs=
+ 1.55902417e-03
+ Gd=
+ 2.04067990e-11

.Model Wmodel_Trace1010::MIPI_DSI1_DATA2_N W MODELTYPE=RLGC N=1
+ Lo=
+ 3.32029740e-07
+ Co=
+ 1.03489020e-10
+ Ro=
+ 3.96831067e+00
+ Go=
+ 0.00000000e+00
+ Rs=
+ 1.55902417e-03
+ Gd=
+ 2.04067990e-11

.Model Wmodel_Trace1012_Auto_1900::MIPI_DSI1_DATA2_N W MODELTYPE=RLGC N=1
+ Lo=
+ 3.32029740e-07
+ Co=
+ 1.03489020e-10
+ Ro=
+ 3.96831067e+00
+ Go=
+ 0.00000000e+00
+ Rs=
+ 1.55902417e-03
+ Gd=
+ 2.04067990e-11

.Model Wmodel_Trace1014::MIPI_DSI1_DATA2_N W MODELTYPE=RLGC N=1
+ Lo=
+ 3.32029740e-07
+ Co=
+ 1.03489020e-10
+ Ro=
+ 3.96831067e+00
+ Go=
+ 0.00000000e+00
+ Rs=
+ 1.55902417e-03
+ Gd=
+ 2.04067990e-11

.Model Wmodel_Trace1024::MIPI_DSI1_DATA2_N W MODELTYPE=RLGC N=2
+ Lo=
+ 3.30748548e-07
+ 4.21643405e-08 3.30748548e-07
+ Co=
+ 1.03807831e-10
+ -4.52139143e-12 1.03807831e-10
+ Ro=
+ 3.96831067e+00
+ 0.00000000e+00 3.96831067e+00
+ Go=
+ 0.00000000e+00
+ -0.00000000e+00 0.00000000e+00
+ Rs=
+ 1.55902417e-03
+ -0.00000000e+00 1.55902417e-03
+ Gd=
+ 2.03827231e-11
+ -1.75180973e-13 2.03827231e-11

.Model Wmodel_Trace1024_Auto_1892::MIPI_DSI1_DATA2_N W MODELTYPE=RLGC N=8
+ Lo=
+ 3.30659850e-07
+ 4.18420962e-08 3.29400569e-07
+ 1.18136088e-08 4.15538169e-08 3.29362789e-07
+ 5.17753113e-09 1.17611110e-08 4.17020244e-08 3.30182737e-07
+ 2.47278566e-09 4.21588952e-09 8.83147567e-09 2.62285483e-08 3.30146570e-07
+ 1.61683658e-09 2.45446604e-09 4.23364287e-09 8.88025339e-09 4.21465131e-08 3.29258685e-07
+ 1.14408454e-09 1.60950136e-09 2.46939055e-09 4.26571330e-09 1.19935227e-08 4.24655955e-08 3.29296365e-07
+ 8.59850741e-10 1.14650820e-09 1.62876185e-09 2.50228562e-09 5.26787043e-09 1.20471705e-08 4.22908901e-08 3.30622415e-07
+ Co=
+ 1.03814480e-10
+ -4.48101291e-12 1.04126982e-10
+ -5.24379587e-13 -4.44260821e-12 1.04130026e-10
+ -2.26467292e-13 -5.17473258e-13 -4.46439984e-12 1.03897853e-10
+ -1.12394046e-13 -1.86611767e-13 -4.06752563e-13 -2.18308652e-12 1.03908784e-10
+ -7.08514756e-14 -1.03545317e-13 -1.78887759e-13 -4.08125174e-13 -4.54079634e-12 1.04162942e-10
+ -5.03911450e-14 -6.80322549e-14 -1.04071642e-13 -1.88177081e-13 -5.24425178e-13 -4.59948758e-12 1.04159990e-10
+ -3.96697021e-14 -5.05894148e-14 -7.14426655e-14 -1.13596399e-13 -2.29444117e-13 -5.31389426e-13 -4.55808937e-12 1.03825609e-10
+ Ro=
+ 3.96831067e+00
+ 0.00000000e+00 3.96831067e+00
+ 0.00000000e+00 0.00000000e+00 3.96831067e+00
+ 0.00000000e+00 0.00000000e+00 0.00000000e+00 3.96831067e+00
+ 0.00000000e+00 0.00000000e+00 0.00000000e+00 0.00000000e+00 3.96831067e+00
+ 0.00000000e+00 0.00000000e+00 0.00000000e+00 0.00000000e+00 0.00000000e+00 3.96831067e+00
+ 0.00000000e+00 0.00000000e+00 0.00000000e+00 0.00000000e+00 0.00000000e+00 0.00000000e+00 3.96831067e+00
+ 0.00000000e+00 0.00000000e+00 0.00000000e+00 0.00000000e+00 0.00000000e+00 0.00000000e+00 0.00000000e+00 3.96831067e+00
+ Go=
+ 0.00000000e+00
+ -0.00000000e+00 0.00000000e+00
+ -0.00000000e+00 -0.00000000e+00 0.00000000e+00
+ -0.00000000e+00 -0.00000000e+00 -0.00000000e+00 0.00000000e+00
+ -0.00000000e+00 -0.00000000e+00 -0.00000000e+00 -0.00000000e+00 0.00000000e+00
+ -0.00000000e+00 -0.00000000e+00 -0.00000000e+00 -0.00000000e+00 -0.00000000e+00 0.00000000e+00
+ -0.00000000e+00 -0.00000000e+00 -0.00000000e+00 -0.00000000e+00 -0.00000000e+00 -0.00000000e+00 0.00000000e+00
+ -0.00000000e+00 -0.00000000e+00 -0.00000000e+00 -0.00000000e+00 -0.00000000e+00 -0.00000000e+00 -0.00000000e+00 0.00000000e+00
+ Rs=
+ 1.55902417e-03
+ -0.00000000e+00 1.55902417e-03
+ -0.00000000e+00 -0.00000000e+00 1.55902417e-03
+ -0.00000000e+00 -0.00000000e+00 -0.00000000e+00 1.55902417e-03
+ -0.00000000e+00 -0.00000000e+00 -0.00000000e+00 -0.00000000e+00 1.55902417e-03
+ -0.00000000e+00 -0.00000000e+00 -0.00000000e+00 -0.00000000e+00 -0.00000000e+00 1.55902417e-03
+ -0.00000000e+00 -0.00000000e+00 -0.00000000e+00 -0.00000000e+00 -0.00000000e+00 -0.00000000e+00 1.55902417e-03
+ -0.00000000e+00 -0.00000000e+00 -0.00000000e+00 -0.00000000e+00 -0.00000000e+00 -0.00000000e+00 -0.00000000e+00 1.55902417e-03
+ Gd=
+ 2.03818287e-11
+ -1.79895809e-13 2.03589747e-11
+ -0.00000000e+00 -1.83631593e-13 2.03585529e-11
+ -0.00000000e+00 -0.00000000e+00 -1.82218005e-13 2.03706772e-11
+ -0.00000000e+00 -0.00000000e+00 -0.00000000e+00 -4.56380380e-16 2.03704056e-11
+ -0.00000000e+00 -0.00000000e+00 -0.00000000e+00 -0.00000000e+00 -1.90243864e-13 2.03577946e-11
+ -0.00000000e+00 -0.00000000e+00 -0.00000000e+00 -0.00000000e+00 -0.00000000e+00 -1.99914822e-13 2.03582138e-11
+ -0.00000000e+00 -0.00000000e+00 -0.00000000e+00 -0.00000000e+00 -0.00000000e+00 -0.00000000e+00 -1.87990216e-13 2.03815391e-11

.Model Wmodel_Trace1024_Auto_1901::MIPI_DSI1_DATA2_N W MODELTYPE=RLGC N=4
+ Lo=
+ 3.30626938e-07
+ 4.22996926e-08 3.29308872e-07
+ 1.20611740e-08 4.24858406e-08 3.29309199e-07
+ 5.30623171e-09 1.20603568e-08 4.22950305e-08 3.30627292e-07
+ Co=
+ 1.03825206e-10
+ -4.55898159e-12 1.04158885e-10
+ -5.32669646e-13 -4.60080799e-12 1.04158775e-10
+ -2.34529497e-13 -5.32641923e-13 -4.55818423e-12 1.03825094e-10
+ Ro=
+ 3.96831067e+00
+ 0.00000000e+00 3.96831067e+00
+ 0.00000000e+00 0.00000000e+00 3.96831067e+00
+ 0.00000000e+00 0.00000000e+00 0.00000000e+00 3.96831067e+00
+ Go=
+ 0.00000000e+00
+ -0.00000000e+00 0.00000000e+00
+ -0.00000000e+00 -0.00000000e+00 0.00000000e+00
+ -0.00000000e+00 -0.00000000e+00 -0.00000000e+00 0.00000000e+00
+ Rs=
+ 1.55902417e-03
+ -0.00000000e+00 1.55902417e-03
+ -0.00000000e+00 -0.00000000e+00 1.55902417e-03
+ -0.00000000e+00 -0.00000000e+00 -0.00000000e+00 1.55902417e-03
+ Gd=
+ 2.03816011e-11
+ -1.87918306e-13 2.03583559e-11
+ -0.00000000e+00 -1.99563417e-13 2.03583583e-11
+ -0.00000000e+00 -0.00000000e+00 -1.87837216e-13 2.03816038e-11

.Model Wmodel_Trace1024_Auto_1902::MIPI_DSI1_DATA2_N W MODELTYPE=RLGC N=1
+ Lo=
+ 3.32029740e-07
+ Co=
+ 1.03489020e-10
+ Ro=
+ 3.96831067e+00
+ Go=
+ 0.00000000e+00
+ Rs=
+ 1.55902417e-03
+ Gd=
+ 2.04067990e-11

.Model Wmodel_Trace1028::MIPI_DSI1_DATA2_N W MODELTYPE=RLGC N=1
+ Lo=
+ 3.32029740e-07
+ Co=
+ 1.03489020e-10
+ Ro=
+ 3.96831067e+00
+ Go=
+ 0.00000000e+00
+ Rs=
+ 1.55902417e-03
+ Gd=
+ 2.04067990e-11

.Model Wmodel_Trace1032::MIPI_DSI1_DATA2_N W MODELTYPE=RLGC N=1
+ Lo=
+ 3.32029740e-07
+ Co=
+ 1.03489020e-10
+ Ro=
+ 3.96831067e+00
+ Go=
+ 0.00000000e+00
+ Rs=
+ 1.55902417e-03
+ Gd=
+ 2.04067990e-11

.Model Wmodel_Trace1034::MIPI_DSI1_DATA2_N W MODELTYPE=RLGC N=1
+ Lo=
+ 3.32029740e-07
+ Co=
+ 1.03489020e-10
+ Ro=
+ 3.96831067e+00
+ Go=
+ 0.00000000e+00
+ Rs=
+ 1.55902417e-03
+ Gd=
+ 2.04067990e-11

.Model Wmodel_Trace1034_Auto_1309::MIPI_DSI1_DATA2_N W MODELTYPE=RLGC N=1
+ Lo=
+ 3.32029740e-07
+ Co=
+ 1.03489020e-10
+ Ro=
+ 3.96831067e+00
+ Go=
+ 0.00000000e+00
+ Rs=
+ 1.55902417e-03
+ Gd=
+ 2.04067990e-11

.Model Wmodel_Trace1036::MIPI_DSI1_DATA2_N W MODELTYPE=RLGC N=1
+ Lo=
+ 3.32029740e-07
+ Co=
+ 1.03489020e-10
+ Ro=
+ 3.96831067e+00
+ Go=
+ 0.00000000e+00
+ Rs=
+ 1.55902417e-03
+ Gd=
+ 2.04067990e-11

.Model Wmodel_Trace1037::MIPI_DSI1_DATA2_N W MODELTYPE=RLGC N=1
+ Lo=
+ 3.32029740e-07
+ Co=
+ 1.03489020e-10
+ Ro=
+ 3.96831067e+00
+ Go=
+ 0.00000000e+00
+ Rs=
+ 1.55902417e-03
+ Gd=
+ 2.04067990e-11

.Model Wmodel_Trace1042::MIPI_DSI1_DATA2_N W MODELTYPE=RLGC N=1
+ Lo=
+ 3.32029740e-07
+ Co=
+ 1.03489020e-10
+ Ro=
+ 3.96831067e+00
+ Go=
+ 0.00000000e+00
+ Rs=
+ 1.55902417e-03
+ Gd=
+ 2.04067990e-11

.Model Wmodel_Trace1054::MIPI_DSI1_DATA2_N W MODELTYPE=RLGC N=1
+ Lo=
+ 3.32029740e-07
+ Co=
+ 1.03489020e-10
+ Ro=
+ 3.96831067e+00
+ Go=
+ 0.00000000e+00
+ Rs=
+ 1.55902417e-03
+ Gd=
+ 2.04067990e-11

.Model Wmodel_Trace1056::MIPI_DSI1_DATA2_N W MODELTYPE=RLGC N=2
+ Lo=
+ 3.31623831e-07
+ 2.58022981e-08 3.31623831e-07
+ Co=
+ 1.03563533e-10
+ -2.13842148e-12 1.03563533e-10
+ Ro=
+ 3.96831067e+00
+ 0.00000000e+00 3.96831067e+00
+ Go=
+ 0.00000000e+00
+ -0.00000000e+00 0.00000000e+00
+ Rs=
+ 1.55902417e-03
+ -0.00000000e+00 1.55902417e-03
+ Gd=
+ 2.03963397e-11
+ -0.00000000e+00 2.03963397e-11

.Model Wmodel_Trace1058::MIPI_DSI1_DATA2_N W MODELTYPE=RLGC N=1
+ Lo=
+ 3.32029740e-07
+ Co=
+ 1.03489020e-10
+ Ro=
+ 3.96831067e+00
+ Go=
+ 0.00000000e+00
+ Rs=
+ 1.55902417e-03
+ Gd=
+ 2.04067990e-11

.Model Wmodel_Trace1062::MIPI_DSI1_DATA2_N W MODELTYPE=RLGC N=1
+ Lo=
+ 8.24350330e-07
+ Co=
+ 3.67394016e-11
+ Ro=
+ 3.96831067e+00
+ Go=
+ 0.00000000e+00
+ Rs=
+ 1.02517469e-03
+ Gd=
+ 6.50321060e-12

.Model Wmodel_Trace1064::MIPI_DSI1_DATA2_N W MODELTYPE=RLGC N=1
+ Lo=
+ 3.32029740e-07
+ Co=
+ 1.03489020e-10
+ Ro=
+ 3.96831067e+00
+ Go=
+ 0.00000000e+00
+ Rs=
+ 1.55902417e-03
+ Gd=
+ 2.04067990e-11

.Model Wmodel_Trace1066#BP0::MIPI_DSI1_DATA2_N W MODELTYPE=RLGC N=1
+ Lo=
+ 3.32029740e-07
+ Co=
+ 1.03489020e-10
+ Ro=
+ 3.96831067e+00
+ Go=
+ 0.00000000e+00
+ Rs=
+ 1.55902417e-03
+ Gd=
+ 2.04067990e-11

.Model Wmodel_Trace1067#BP0::MIPI_DSI1_DATA2_N W MODELTYPE=RLGC N=1
+ Lo=
+ 8.24350330e-07
+ Co=
+ 3.67394016e-11
+ Ro=
+ 3.96831067e+00
+ Go=
+ 0.00000000e+00
+ Rs=
+ 1.02517469e-03
+ Gd=
+ 6.50321060e-12

.Model Wmodel_Trace1067#BP1::MIPI_DSI1_DATA2_N W MODELTYPE=RLGC N=1
+ Lo=
+ 3.32029740e-07
+ Co=
+ 1.03489020e-10
+ Ro=
+ 3.96831067e+00
+ Go=
+ 0.00000000e+00
+ Rs=
+ 1.55902417e-03
+ Gd=
+ 2.04067990e-11

.Model Wmodel_Trace1067_Auto_1355::MIPI_DSI1_DATA2_N W MODELTYPE=RLGC N=1
+ Lo=
+ 3.32029740e-07
+ Co=
+ 1.03489020e-10
+ Ro=
+ 3.96831067e+00
+ Go=
+ 0.00000000e+00
+ Rs=
+ 1.55902417e-03
+ Gd=
+ 2.04067990e-11

.Model Wmodel_Trace1069::MIPI_DSI1_DATA2_N W MODELTYPE=RLGC N=1
+ Lo=
+ 3.32029740e-07
+ Co=
+ 1.03489020e-10
+ Ro=
+ 3.96831067e+00
+ Go=
+ 0.00000000e+00
+ Rs=
+ 1.55902417e-03
+ Gd=
+ 2.04067990e-11

.Model Wmodel_Trace1091::MIPI_DSI1_DATA2_N W MODELTYPE=RLGC N=1
+ Lo=
+ 3.32029740e-07
+ Co=
+ 1.03489020e-10
+ Ro=
+ 3.96831067e+00
+ Go=
+ 0.00000000e+00
+ Rs=
+ 1.55902417e-03
+ Gd=
+ 2.04067990e-11

.Model Wmodel_Trace1113::MIPI_DSI1_DATA2_N W MODELTYPE=RLGC N=1
+ Lo=
+ 3.32029740e-07
+ Co=
+ 1.03489020e-10
+ Ro=
+ 3.96831067e+00
+ Go=
+ 0.00000000e+00
+ Rs=
+ 1.55902417e-03
+ Gd=
+ 2.04067990e-11

.Model Wmodel_Trace1135::MIPI_DSI1_DATA2_N W MODELTYPE=RLGC N=1
+ Lo=
+ 3.32029740e-07
+ Co=
+ 1.03489020e-10
+ Ro=
+ 3.96831067e+00
+ Go=
+ 0.00000000e+00
+ Rs=
+ 1.55902417e-03
+ Gd=
+ 2.04067990e-11

.Model Wmodel_Trace1157::MIPI_DSI1_DATA2_N W MODELTYPE=RLGC N=1
+ Lo=
+ 3.32029740e-07
+ Co=
+ 1.03489020e-10
+ Ro=
+ 3.96831067e+00
+ Go=
+ 0.00000000e+00
+ Rs=
+ 1.55902417e-03
+ Gd=
+ 2.04067990e-11

.Model Wmodel_Trace1179::MIPI_DSI1_DATA2_N W MODELTYPE=RLGC N=1
+ Lo=
+ 3.32029740e-07
+ Co=
+ 1.03489020e-10
+ Ro=
+ 3.96831067e+00
+ Go=
+ 0.00000000e+00
+ Rs=
+ 1.55902417e-03
+ Gd=
+ 2.04067990e-11

.Model Wmodel_Trace1181::MIPI_DSI1_DATA2_N W MODELTYPE=RLGC N=1
+ Lo=
+ 3.32029740e-07
+ Co=
+ 1.03489020e-10
+ Ro=
+ 3.96831067e+00
+ Go=
+ 0.00000000e+00
+ Rs=
+ 1.55902417e-03
+ Gd=
+ 2.04067990e-11

.Model Wmodel_Trace1181_Auto_1450::MIPI_DSI1_DATA2_N W MODELTYPE=RLGC N=1
+ Lo=
+ 3.32029740e-07
+ Co=
+ 1.03489020e-10
+ Ro=
+ 3.96831067e+00
+ Go=
+ 0.00000000e+00
+ Rs=
+ 1.55902417e-03
+ Gd=
+ 2.04067990e-11

.Model Wmodel_Trace1183::MIPI_DSI1_DATA2_N W MODELTYPE=RLGC N=1
+ Lo=
+ 3.32029740e-07
+ Co=
+ 1.03489020e-10
+ Ro=
+ 3.96831067e+00
+ Go=
+ 0.00000000e+00
+ Rs=
+ 1.55902417e-03
+ Gd=
+ 2.04067990e-11

.Model Wmodel_Trace1185::MIPI_DSI1_DATA2_N W MODELTYPE=RLGC N=1
+ Lo=
+ 3.32029740e-07
+ Co=
+ 1.03489020e-10
+ Ro=
+ 3.96831067e+00
+ Go=
+ 0.00000000e+00
+ Rs=
+ 1.55902417e-03
+ Gd=
+ 2.04067990e-11

.Model Wmodel_Trace1186_Auto_1689::MIPI_DSI1_DATA2_N W MODELTYPE=RLGC N=1
+ Lo=
+ 3.32029740e-07
+ Co=
+ 1.03489020e-10
+ Ro=
+ 3.96831067e+00
+ Go=
+ 0.00000000e+00
+ Rs=
+ 1.55902417e-03
+ Gd=
+ 2.04067990e-11

.Model Wmodel_Trace1187::MIPI_DSI1_DATA2_P W MODELTYPE=RLGC N=1
+ Lo=
+ 3.58484574e-07
+ Co=
+ 9.37055974e-11
+ Ro=
+ 4.84133902e+00
+ Go=
+ 0.00000000e+00
+ Rs=
+ 1.72420198e-03
+ Gd=
+ 1.82370500e-11

.Model Wmodel_Trace1188::MIPI_DSI1_DATA2_P W MODELTYPE=RLGC N=5
+ Lo=
+ 3.31205492e-07
+ 3.27866706e-08 3.28608437e-07
+ 1.20067156e-08 5.58510416e-08 3.27984681e-07
+ 5.15439670e-09 1.38563749e-08 4.10104701e-08 3.27269033e-07
+ 2.91009086e-09 5.88187506e-09 1.21389857e-08 4.55472273e-08 2.63692745e-07
+ Co=
+ 1.03650850e-10
+ -3.06208787e-12 1.04441654e-10
+ -5.20897776e-13 -7.14326233e-12 1.04606364e-10
+ -2.25557884e-13 -5.67510509e-13 -4.39928681e-12 1.04510958e-10
+ -1.71158500e-13 -3.08269958e-13 -6.72625118e-13 -7.02639460e-12 1.38292498e-10
+ Ro=
+ 3.96831067e+00
+ 0.00000000e+00 3.96831067e+00
+ 0.00000000e+00 0.00000000e+00 3.96831067e+00
+ 0.00000000e+00 0.00000000e+00 0.00000000e+00 3.96831067e+00
+ 0.00000000e+00 0.00000000e+00 0.00000000e+00 0.00000000e+00 2.42066951e+00
+ Go=
+ 0.00000000e+00
+ -0.00000000e+00 0.00000000e+00
+ -0.00000000e+00 -0.00000000e+00 0.00000000e+00
+ -0.00000000e+00 -0.00000000e+00 -0.00000000e+00 0.00000000e+00
+ -0.00000000e+00 -0.00000000e+00 -0.00000000e+00 -0.00000000e+00 0.00000000e+00
+ Rs=
+ 1.55902417e-03
+ -0.00000000e+00 1.55902417e-03
+ -0.00000000e+00 -0.00000000e+00 1.55902417e-03
+ -0.00000000e+00 -0.00000000e+00 -0.00000000e+00 1.55902417e-03
+ -0.00000000e+00 -0.00000000e+00 -0.00000000e+00 -0.00000000e+00 1.18814509e-03
+ Gd=
+ 2.03888531e-11
+ -5.58202686e-14 2.03665063e-11
+ -0.00000000e+00 -4.88588953e-13 2.03595553e-11
+ -0.00000000e+00 -0.00000000e+00 -1.87389917e-13 2.03575161e-11
+ -0.00000000e+00 -0.00000000e+00 -0.00000000e+00 -4.29099927e-13 2.79835704e-11

.Model Wmodel_Trace1188_Auto_790::MIPI_DSI1_DATA2_P W MODELTYPE=RLGC N=5
+ Lo=
+ 3.30942891e-07
+ 3.74936670e-08 3.29166136e-07
+ 1.19799041e-08 4.77481021e-08 3.28774593e-07
+ 5.15570969e-09 1.26222105e-08 4.11290992e-08 3.27288187e-07
+ 2.91020183e-09 5.52453976e-09 1.21741297e-08 4.55531871e-08 2.63694640e-07
+ Co=
+ 1.03725430e-10
+ -3.77157128e-12 1.04208560e-10
+ -5.27418630e-13 -5.55092112e-12 1.04301885e-10
+ -2.22610211e-13 -5.33501532e-13 -4.41409019e-12 1.04510232e-10
+ -1.69062766e-13 -2.97751398e-13 -6.79654112e-13 -7.02670747e-12 1.38292372e-10
+ Ro=
+ 3.96831067e+00
+ 0.00000000e+00 3.96831067e+00
+ 0.00000000e+00 0.00000000e+00 3.96831067e+00
+ 0.00000000e+00 0.00000000e+00 0.00000000e+00 3.96831067e+00
+ 0.00000000e+00 0.00000000e+00 0.00000000e+00 0.00000000e+00 2.42066951e+00
+ Go=
+ 0.00000000e+00
+ -0.00000000e+00 0.00000000e+00
+ -0.00000000e+00 -0.00000000e+00 0.00000000e+00
+ -0.00000000e+00 -0.00000000e+00 -0.00000000e+00 0.00000000e+00
+ -0.00000000e+00 -0.00000000e+00 -0.00000000e+00 -0.00000000e+00 0.00000000e+00
+ Rs=
+ 1.55902417e-03
+ -0.00000000e+00 1.55902417e-03
+ -0.00000000e+00 -0.00000000e+00 1.55902417e-03
+ -0.00000000e+00 -0.00000000e+00 -0.00000000e+00 1.55902417e-03
+ -0.00000000e+00 -0.00000000e+00 -0.00000000e+00 -0.00000000e+00 1.18814509e-03
+ Gd=
+ 2.03848602e-11
+ -1.13646324e-13 2.03596450e-11
+ -0.00000000e+00 -3.01350125e-13 2.03562342e-11
+ -0.00000000e+00 -0.00000000e+00 -1.86525732e-13 2.03575725e-11
+ -0.00000000e+00 -0.00000000e+00 -0.00000000e+00 -4.29076740e-13 2.79835790e-11

.Model Wmodel_Trace1189::MIPI_DSI1_DATA2_P W MODELTYPE=RLGC N=1
+ Lo=
+ 3.32029740e-07
+ Co=
+ 1.03489020e-10
+ Ro=
+ 3.96831067e+00
+ Go=
+ 0.00000000e+00
+ Rs=
+ 1.55902417e-03
+ Gd=
+ 2.04067990e-11

.Model Wmodel_Trace1190::MIPI_DSI1_DATA2_P W MODELTYPE=RLGC N=5
+ Lo=
+ 3.30642636e-07
+ 4.17465617e-08 3.28883789e-07
+ 1.28133922e-08 4.76917776e-08 3.28762732e-07
+ 5.38930908e-09 1.26055254e-08 4.11254422e-08 3.27287038e-07
+ 3.00654530e-09 5.51712031e-09 1.21724595e-08 4.55526584e-08 2.63694397e-07
+ Co=
+ 1.03815123e-10
+ -4.46906019e-12 1.04296323e-10
+ -5.53869310e-13 -5.54387182e-12 1.04302422e-10
+ -2.28958320e-13 -5.30959608e-13 -4.41391317e-12 1.04510287e-10
+ -1.72180810e-13 -2.95970986e-13 -6.79537437e-13 -7.02667298e-12 1.38292393e-10
+ Ro=
+ 3.96831067e+00
+ 0.00000000e+00 3.96831067e+00
+ 0.00000000e+00 0.00000000e+00 3.96831067e+00
+ 0.00000000e+00 0.00000000e+00 0.00000000e+00 3.96831067e+00
+ 0.00000000e+00 0.00000000e+00 0.00000000e+00 0.00000000e+00 2.42066951e+00
+ Go=
+ 0.00000000e+00
+ -0.00000000e+00 0.00000000e+00
+ -0.00000000e+00 -0.00000000e+00 0.00000000e+00
+ -0.00000000e+00 -0.00000000e+00 -0.00000000e+00 0.00000000e+00
+ -0.00000000e+00 -0.00000000e+00 -0.00000000e+00 -0.00000000e+00 0.00000000e+00
+ Rs=
+ 1.55902417e-03
+ -0.00000000e+00 1.55902417e-03
+ -0.00000000e+00 -0.00000000e+00 1.55902417e-03
+ -0.00000000e+00 -0.00000000e+00 -0.00000000e+00 1.55902417e-03
+ -0.00000000e+00 -0.00000000e+00 -0.00000000e+00 -0.00000000e+00 1.18814509e-03
+ Gd=
+ 2.03817673e-11
+ -1.80619620e-13 2.03568337e-11
+ -0.00000000e+00 -3.01902980e-13 2.03561846e-11
+ -0.00000000e+00 -0.00000000e+00 -1.86541384e-13 2.03575680e-11
+ -0.00000000e+00 -0.00000000e+00 -0.00000000e+00 -4.29079390e-13 2.79835776e-11

.Model Wmodel_Trace1191::MIPI_DSI1_DATA2_P W MODELTYPE=RLGC N=1
+ Lo=
+ 3.32029740e-07
+ Co=
+ 1.03489020e-10
+ Ro=
+ 3.96831067e+00
+ Go=
+ 0.00000000e+00
+ Rs=
+ 1.55902417e-03
+ Gd=
+ 2.04067990e-11

.Model Wmodel_Trace1192::MIPI_DSI1_DATA2_P W MODELTYPE=RLGC N=5
+ Lo=
+ 3.30942891e-07
+ 3.74936670e-08 3.29166136e-07
+ 1.19799041e-08 4.77481021e-08 3.28774593e-07
+ 5.15570969e-09 1.26222105e-08 4.11290992e-08 3.27288187e-07
+ 2.91020183e-09 5.52453976e-09 1.21741297e-08 4.55531871e-08 2.63694640e-07
+ Co=
+ 1.03725430e-10
+ -3.77157128e-12 1.04208560e-10
+ -5.27418630e-13 -5.55092112e-12 1.04301885e-10
+ -2.22610211e-13 -5.33501532e-13 -4.41409019e-12 1.04510232e-10
+ -1.69062766e-13 -2.97751398e-13 -6.79654112e-13 -7.02670747e-12 1.38292372e-10
+ Ro=
+ 3.96831067e+00
+ 0.00000000e+00 3.96831067e+00
+ 0.00000000e+00 0.00000000e+00 3.96831067e+00
+ 0.00000000e+00 0.00000000e+00 0.00000000e+00 3.96831067e+00
+ 0.00000000e+00 0.00000000e+00 0.00000000e+00 0.00000000e+00 2.42066951e+00
+ Go=
+ 0.00000000e+00
+ -0.00000000e+00 0.00000000e+00
+ -0.00000000e+00 -0.00000000e+00 0.00000000e+00
+ -0.00000000e+00 -0.00000000e+00 -0.00000000e+00 0.00000000e+00
+ -0.00000000e+00 -0.00000000e+00 -0.00000000e+00 -0.00000000e+00 0.00000000e+00
+ Rs=
+ 1.55902417e-03
+ -0.00000000e+00 1.55902417e-03
+ -0.00000000e+00 -0.00000000e+00 1.55902417e-03
+ -0.00000000e+00 -0.00000000e+00 -0.00000000e+00 1.55902417e-03
+ -0.00000000e+00 -0.00000000e+00 -0.00000000e+00 -0.00000000e+00 1.18814509e-03
+ Gd=
+ 2.03848602e-11
+ -1.13646324e-13 2.03596450e-11
+ -0.00000000e+00 -3.01350125e-13 2.03562342e-11
+ -0.00000000e+00 -0.00000000e+00 -1.86525732e-13 2.03575725e-11
+ -0.00000000e+00 -0.00000000e+00 -0.00000000e+00 -4.29076740e-13 2.79835790e-11

.Model Wmodel_Trace1192_Auto_758::MIPI_DSI1_DATA2_P W MODELTYPE=RLGC N=1
+ Lo=
+ 3.32029740e-07
+ Co=
+ 1.03489020e-10
+ Ro=
+ 3.96831067e+00
+ Go=
+ 0.00000000e+00
+ Rs=
+ 1.55902417e-03
+ Gd=
+ 2.04067990e-11

.Model Wmodel_Trace1193::MIPI_DSI1_DATA2_P W MODELTYPE=RLGC N=4
+ Lo=
+ 3.30659715e-07
+ 4.18249378e-08 3.29272964e-07
+ 1.21350699e-08 4.34040955e-08 3.29272964e-07
+ 5.30322955e-09 1.21350699e-08 4.18249378e-08 3.30659715e-07
+ Co=
+ 1.03814284e-10
+ -4.47850988e-12 1.04170740e-10
+ -5.35092318e-13 -4.76008133e-12 1.04170740e-10
+ -2.35057088e-13 -5.35092318e-13 -4.47850988e-12 1.03814284e-10
+ Ro=
+ 3.96831067e+00
+ 0.00000000e+00 3.96831067e+00
+ 0.00000000e+00 0.00000000e+00 3.96831067e+00
+ 0.00000000e+00 0.00000000e+00 0.00000000e+00 3.96831067e+00
+ Go=
+ 0.00000000e+00
+ -0.00000000e+00 0.00000000e+00
+ -0.00000000e+00 -0.00000000e+00 0.00000000e+00
+ -0.00000000e+00 -0.00000000e+00 -0.00000000e+00 0.00000000e+00
+ Rs=
+ 1.55902417e-03
+ -0.00000000e+00 1.55902417e-03
+ -0.00000000e+00 -0.00000000e+00 1.55902417e-03
+ -0.00000000e+00 -0.00000000e+00 -0.00000000e+00 1.55902417e-03
+ Gd=
+ 2.03818679e-11
+ -1.80048190e-13 2.03581722e-11
+ -0.00000000e+00 -2.15849940e-13 2.03581722e-11
+ -0.00000000e+00 -0.00000000e+00 -1.80048190e-13 2.03818679e-11

.Model Wmodel_Trace1194::MIPI_DSI1_DATA2_P W MODELTYPE=RLGC N=2
+ Lo=
+ 3.30748904e-07
+ 4.21593990e-08 3.30748904e-07
+ Co=
+ 1.03807716e-10
+ -4.52055469e-12 1.03807716e-10
+ Ro=
+ 3.96831067e+00
+ 0.00000000e+00 3.96831067e+00
+ Go=
+ 0.00000000e+00
+ -0.00000000e+00 0.00000000e+00
+ Rs=
+ 1.55902417e-03
+ -0.00000000e+00 1.55902417e-03
+ Gd=
+ 2.03827260e-11
+ -1.75097034e-13 2.03827260e-11

.Model Wmodel_Trace1194_Auto_1237::MIPI_DSI1_DATA2_P W MODELTYPE=RLGC N=1
+ Lo=
+ 3.32029740e-07
+ Co=
+ 1.03489020e-10
+ Ro=
+ 3.96831067e+00
+ Go=
+ 0.00000000e+00
+ Rs=
+ 1.55902417e-03
+ Gd=
+ 2.04067990e-11

.Model Wmodel_Trace1198::MIPI_DSI1_DATA2_P W MODELTYPE=RLGC N=1
+ Lo=
+ 3.32029740e-07
+ Co=
+ 1.03489020e-10
+ Ro=
+ 3.96831067e+00
+ Go=
+ 0.00000000e+00
+ Rs=
+ 1.55902417e-03
+ Gd=
+ 2.04067990e-11

.Model Wmodel_Trace1208#BP0::MIPI_DSI1_DATA2_P W MODELTYPE=RLGC N=1
+ Lo=
+ 8.24350330e-07
+ Co=
+ 3.67394016e-11
+ Ro=
+ 3.96831067e+00
+ Go=
+ 0.00000000e+00
+ Rs=
+ 1.02517469e-03
+ Gd=
+ 6.50321060e-12

.Model Wmodel_Trace1208#BP1::MIPI_DSI1_DATA2_P W MODELTYPE=RLGC N=1
+ Lo=
+ 3.32029740e-07
+ Co=
+ 1.03489020e-10
+ Ro=
+ 3.96831067e+00
+ Go=
+ 0.00000000e+00
+ Rs=
+ 1.55902417e-03
+ Gd=
+ 2.04067990e-11

.Model Wmodel_Trace1208#BP1_Auto_1877::MIPI_DSI1_DATA2_P W MODELTYPE=RLGC N=2
+ Lo=
+ 3.30748904e-07
+ 4.21593990e-08 3.30748904e-07
+ Co=
+ 1.03807716e-10
+ -4.52055469e-12 1.03807716e-10
+ Ro=
+ 3.96831067e+00
+ 0.00000000e+00 3.96831067e+00
+ Go=
+ 0.00000000e+00
+ -0.00000000e+00 0.00000000e+00
+ Rs=
+ 1.55902417e-03
+ -0.00000000e+00 1.55902417e-03
+ Gd=
+ 2.03827260e-11
+ -1.75097034e-13 2.03827260e-11

.Model Wmodel_Trace1208::MIPI_DSI1_DATA2_P W MODELTYPE=RLGC N=1
+ Lo=
+ 3.32029740e-07
+ Co=
+ 1.03489020e-10
+ Ro=
+ 3.96831067e+00
+ Go=
+ 0.00000000e+00
+ Rs=
+ 1.55902417e-03
+ Gd=
+ 2.04067990e-11

.Model Wmodel_Trace1209::MIPI_DSI1_DATA2_P W MODELTYPE=RLGC N=2
+ Lo=
+ 3.31032063e-07
+ 3.79301273e-08 3.31032063e-07
+ Co=
+ 1.03719639e-10
+ -3.82925212e-12 1.03719639e-10
+ Ro=
+ 3.96831067e+00
+ 0.00000000e+00 3.96831067e+00
+ Go=
+ 0.00000000e+00
+ -0.00000000e+00 0.00000000e+00
+ Rs=
+ 1.55902417e-03
+ -0.00000000e+00 1.55902417e-03
+ Gd=
+ 2.03857107e-11
+ -1.09077726e-13 2.03857107e-11

.Model Wmodel_Trace1210::MIPI_DSI1_DATA2_P W MODELTYPE=RLGC N=1
+ Lo=
+ 3.32029740e-07
+ Co=
+ 1.03489020e-10
+ Ro=
+ 3.96831067e+00
+ Go=
+ 0.00000000e+00
+ Rs=
+ 1.55902417e-03
+ Gd=
+ 2.04067990e-11

.Model Wmodel_Trace1210_Auto_1875::MIPI_DSI1_DATA2_P W MODELTYPE=RLGC N=2
+ Lo=
+ 3.31255706e-07
+ 3.40486162e-08 3.31255706e-07
+ Co=
+ 1.03655649e-10
+ -3.23974310e-12 1.03655649e-10
+ Ro=
+ 3.96831067e+00
+ 0.00000000e+00 3.96831067e+00
+ Go=
+ 0.00000000e+00
+ -0.00000000e+00 0.00000000e+00
+ Rs=
+ 1.55902417e-03
+ -0.00000000e+00 1.55902417e-03
+ Gd=
+ 2.03890053e-11
+ -5.89962403e-14 2.03890053e-11

.Model Wmodel_Trace1211::MIPI_DSI1_DATA2_P W MODELTYPE=RLGC N=1
+ Lo=
+ 3.32029740e-07
+ Co=
+ 1.03489020e-10
+ Ro=
+ 3.96831067e+00
+ Go=
+ 0.00000000e+00
+ Rs=
+ 1.55902417e-03
+ Gd=
+ 2.04067990e-11

.Model Wmodel_Trace1213::MIPI_DSI1_DATA2_P W MODELTYPE=RLGC N=1
+ Lo=
+ 3.32029740e-07
+ Co=
+ 1.03489020e-10
+ Ro=
+ 3.96831067e+00
+ Go=
+ 0.00000000e+00
+ Rs=
+ 1.55902417e-03
+ Gd=
+ 2.04067990e-11

.Model Wmodel_Trace1218::MIPI_DSI1_DATA2_P W MODELTYPE=RLGC N=1
+ Lo=
+ 3.32029740e-07
+ Co=
+ 1.03489020e-10
+ Ro=
+ 3.96831067e+00
+ Go=
+ 0.00000000e+00
+ Rs=
+ 1.55902417e-03
+ Gd=
+ 2.04067990e-11

.Model Wmodel_Trace1223::MIPI_DSI1_DATA2_P W MODELTYPE=RLGC N=1
+ Lo=
+ 3.32029740e-07
+ Co=
+ 1.03489020e-10
+ Ro=
+ 3.96831067e+00
+ Go=
+ 0.00000000e+00
+ Rs=
+ 1.55902417e-03
+ Gd=
+ 2.04067990e-11

.Model Wmodel_Trace1225::MIPI_DSI1_DATA2_P W MODELTYPE=RLGC N=1
+ Lo=
+ 3.32029740e-07
+ Co=
+ 1.03489020e-10
+ Ro=
+ 3.96831067e+00
+ Go=
+ 0.00000000e+00
+ Rs=
+ 1.55902417e-03
+ Gd=
+ 2.04067990e-11

.Model Wmodel_Trace1227::MIPI_DSI1_DATA2_P W MODELTYPE=RLGC N=1
+ Lo=
+ 3.32029740e-07
+ Co=
+ 1.03489020e-10
+ Ro=
+ 3.96831067e+00
+ Go=
+ 0.00000000e+00
+ Rs=
+ 1.55902417e-03
+ Gd=
+ 2.04067990e-11

.Model Wmodel_Trace1236::MIPI_DSI1_DATA2_P W MODELTYPE=RLGC N=1
+ Lo=
+ 3.32029740e-07
+ Co=
+ 1.03489020e-10
+ Ro=
+ 3.96831067e+00
+ Go=
+ 0.00000000e+00
+ Rs=
+ 1.55902417e-03
+ Gd=
+ 2.04067990e-11

.Model Wmodel_Trace1236_Auto_1895::MIPI_DSI1_DATA2_P W MODELTYPE=RLGC N=4
+ Lo=
+ 3.30664868e-07
+ 4.24702196e-08 3.30198588e-07
+ 9.22531587e-09 2.73685101e-08 3.30192007e-07
+ 4.43832837e-09 9.23599971e-09 4.25617026e-08 3.30658055e-07
+ Co=
+ 1.03822926e-10
+ -4.58082074e-12 1.03911677e-10
+ -4.33089682e-13 -2.32345756e-12 1.03913853e-10
+ -1.99094792e-13 -4.33478475e-13 -4.59645283e-12 1.03825123e-10
+ Ro=
+ 3.96831067e+00
+ 0.00000000e+00 3.96831067e+00
+ 0.00000000e+00 0.00000000e+00 3.96831067e+00
+ 0.00000000e+00 0.00000000e+00 0.00000000e+00 3.96831067e+00
+ Go=
+ 0.00000000e+00
+ -0.00000000e+00 0.00000000e+00
+ -0.00000000e+00 -0.00000000e+00 0.00000000e+00
+ -0.00000000e+00 -0.00000000e+00 -0.00000000e+00 0.00000000e+00
+ Rs=
+ 1.55902417e-03
+ -0.00000000e+00 1.55902417e-03
+ -0.00000000e+00 -0.00000000e+00 1.55902417e-03
+ -0.00000000e+00 -0.00000000e+00 -0.00000000e+00 1.55902417e-03
+ Gd=
+ 2.03818420e-11
+ -1.85712696e-13 2.03703885e-11
+ -0.00000000e+00 -7.54572908e-15 2.03703391e-11
+ -0.00000000e+00 -0.00000000e+00 -1.87300246e-13 2.03817894e-11

.Model Wmodel_Trace1246::MIPI_DSI1_DATA2_P W MODELTYPE=RLGC N=1
+ Lo=
+ 3.32029740e-07
+ Co=
+ 1.03489020e-10
+ Ro=
+ 3.96831067e+00
+ Go=
+ 0.00000000e+00
+ Rs=
+ 1.55902417e-03
+ Gd=
+ 2.04067990e-11

.Model Wmodel_Trace1248::MIPI_DSI1_DATA2_P W MODELTYPE=RLGC N=1
+ Lo=
+ 3.32029740e-07
+ Co=
+ 1.03489020e-10
+ Ro=
+ 3.96831067e+00
+ Go=
+ 0.00000000e+00
+ Rs=
+ 1.55902417e-03
+ Gd=
+ 2.04067990e-11

.Model Wmodel_Trace1252::MIPI_DSI1_DATA2_P W MODELTYPE=RLGC N=1
+ Lo=
+ 3.32029740e-07
+ Co=
+ 1.03489020e-10
+ Ro=
+ 3.96831067e+00
+ Go=
+ 0.00000000e+00
+ Rs=
+ 1.55902417e-03
+ Gd=
+ 2.04067990e-11

.Model Wmodel_Trace1253::MIPI_DSI1_DATA2_P W MODELTYPE=RLGC N=1
+ Lo=
+ 3.32029740e-07
+ Co=
+ 1.03489020e-10
+ Ro=
+ 3.96831067e+00
+ Go=
+ 0.00000000e+00
+ Rs=
+ 1.55902417e-03
+ Gd=
+ 2.04067990e-11

.Model Wmodel_Trace1253_Auto_1244::MIPI_DSI1_DATA2_P W MODELTYPE=RLGC N=2
+ Lo=
+ 3.30748548e-07
+ 4.21643405e-08 3.30748548e-07
+ Co=
+ 1.03807831e-10
+ -4.52139143e-12 1.03807831e-10
+ Ro=
+ 3.96831067e+00
+ 0.00000000e+00 3.96831067e+00
+ Go=
+ 0.00000000e+00
+ -0.00000000e+00 0.00000000e+00
+ Rs=
+ 1.55902417e-03
+ -0.00000000e+00 1.55902417e-03
+ Gd=
+ 2.03827231e-11
+ -1.75180973e-13 2.03827231e-11

.Model Wmodel_Trace1255::MIPI_DSI1_DATA2_P W MODELTYPE=RLGC N=1
+ Lo=
+ 3.32029740e-07
+ Co=
+ 1.03489020e-10
+ Ro=
+ 3.96831067e+00
+ Go=
+ 0.00000000e+00
+ Rs=
+ 1.55902417e-03
+ Gd=
+ 2.04067990e-11

.Model Wmodel_Trace1258::MIPI_DSI1_DATA2_P W MODELTYPE=RLGC N=1
+ Lo=
+ 3.32029740e-07
+ Co=
+ 1.03489020e-10
+ Ro=
+ 3.96831067e+00
+ Go=
+ 0.00000000e+00
+ Rs=
+ 1.55902417e-03
+ Gd=
+ 2.04067990e-11

.Model Wmodel_Trace1258_Auto_1307::MIPI_DSI1_DATA2_P W MODELTYPE=RLGC N=2
+ Lo=
+ 3.30706509e-07
+ 4.27426274e-08 3.30706509e-07
+ Co=
+ 1.03821510e-10
+ -4.61977037e-12 1.03821510e-10
+ Ro=
+ 3.96831067e+00
+ 0.00000000e+00 3.96831067e+00
+ Go=
+ 0.00000000e+00
+ -0.00000000e+00 0.00000000e+00
+ Rs=
+ 1.55902417e-03
+ -0.00000000e+00 1.55902417e-03
+ Gd=
+ 2.03823877e-11
+ -1.85111578e-13 2.03823877e-11

.Model Wmodel_Trace1260::MIPI_DSI1_DATA2_P W MODELTYPE=RLGC N=1
+ Lo=
+ 3.32029740e-07
+ Co=
+ 1.03489020e-10
+ Ro=
+ 3.96831067e+00
+ Go=
+ 0.00000000e+00
+ Rs=
+ 1.55902417e-03
+ Gd=
+ 2.04067990e-11

.Model Wmodel_Trace1262#BP0::MIPI_DSI1_DATA2_P W MODELTYPE=RLGC N=1
+ Lo=
+ 8.24350330e-07
+ Co=
+ 3.67394016e-11
+ Ro=
+ 3.96831067e+00
+ Go=
+ 0.00000000e+00
+ Rs=
+ 1.02517469e-03
+ Gd=
+ 6.50321060e-12

.Model Wmodel_Trace1262#BP1::MIPI_DSI1_DATA2_P W MODELTYPE=RLGC N=1
+ Lo=
+ 3.32029740e-07
+ Co=
+ 1.03489020e-10
+ Ro=
+ 3.96831067e+00
+ Go=
+ 0.00000000e+00
+ Rs=
+ 1.55902417e-03
+ Gd=
+ 2.04067990e-11

.Model Wmodel_Trace1262::MIPI_DSI1_DATA2_P W MODELTYPE=RLGC N=2
+ Lo=
+ 3.30784836e-07
+ 4.16559655e-08 3.30784836e-07
+ Co=
+ 1.03796142e-10
+ -4.43566005e-12 1.03796142e-10
+ Ro=
+ 3.96831067e+00
+ 0.00000000e+00 3.96831067e+00
+ Go=
+ 0.00000000e+00
+ -0.00000000e+00 0.00000000e+00
+ Rs=
+ 1.55902417e-03
+ -0.00000000e+00 1.55902417e-03
+ Gd=
+ 2.03830344e-11
+ -1.66627638e-13 2.03830344e-11

.Model Wmodel_Trace1262_Auto_1306::MIPI_DSI1_DATA2_P W MODELTYPE=RLGC N=1
+ Lo=
+ 3.32029740e-07
+ Co=
+ 1.03489020e-10
+ Ro=
+ 3.96831067e+00
+ Go=
+ 0.00000000e+00
+ Rs=
+ 1.55902417e-03
+ Gd=
+ 2.04067990e-11

.Model Wmodel_Trace1266::MIPI_DSI1_DATA2_P W MODELTYPE=RLGC N=2
+ Lo=
+ 3.30739043e-07
+ 4.22960763e-08 3.30739043e-07
+ Co=
+ 1.03810911e-10
+ -4.54372237e-12 1.03810911e-10
+ Ro=
+ 3.96831067e+00
+ 0.00000000e+00 3.96831067e+00
+ Go=
+ 0.00000000e+00
+ -0.00000000e+00 0.00000000e+00
+ Rs=
+ 1.55902417e-03
+ -0.00000000e+00 1.55902417e-03
+ Gd=
+ 2.03826449e-11
+ -1.77424428e-13 2.03826449e-11

.Model Wmodel_Trace1266_Auto_1353::MIPI_DSI1_DATA2_P W MODELTYPE=RLGC N=1
+ Lo=
+ 3.32029740e-07
+ Co=
+ 1.03489020e-10
+ Ro=
+ 3.96831067e+00
+ Go=
+ 0.00000000e+00
+ Rs=
+ 1.55902417e-03
+ Gd=
+ 2.04067990e-11

.Model Wmodel_Trace1267::MIPI_DSI1_DATA2_P W MODELTYPE=RLGC N=1
+ Lo=
+ 3.32029740e-07
+ Co=
+ 1.03489020e-10
+ Ro=
+ 3.96831067e+00
+ Go=
+ 0.00000000e+00
+ Rs=
+ 1.55902417e-03
+ Gd=
+ 2.04067990e-11

.Model Wmodel_Trace1267_Auto_1354::MIPI_DSI1_DATA2_P W MODELTYPE=RLGC N=2
+ Lo=
+ 3.30791524e-07
+ 4.15613158e-08 3.30791524e-07
+ Co=
+ 1.03794000e-10
+ -4.41977676e-12 1.03794000e-10
+ Ro=
+ 3.96831067e+00
+ 0.00000000e+00 3.96831067e+00
+ Go=
+ 0.00000000e+00
+ -0.00000000e+00 0.00000000e+00
+ Rs=
+ 1.55902417e-03
+ -0.00000000e+00 1.55902417e-03
+ Gd=
+ 2.03830940e-11
+ -1.65053512e-13 2.03830940e-11

.Model Wmodel_Trace1271::MIPI_DSI1_DATA2_P W MODELTYPE=RLGC N=1
+ Lo=
+ 3.32029740e-07
+ Co=
+ 1.03489020e-10
+ Ro=
+ 3.96831067e+00
+ Go=
+ 0.00000000e+00
+ Rs=
+ 1.55902417e-03
+ Gd=
+ 2.04067990e-11

.Model Wmodel_Trace1282::MIPI_DSI1_DATA2_P W MODELTYPE=RLGC N=1
+ Lo=
+ 3.32029740e-07
+ Co=
+ 1.03489020e-10
+ Ro=
+ 3.96831067e+00
+ Go=
+ 0.00000000e+00
+ Rs=
+ 1.55902417e-03
+ Gd=
+ 2.04067990e-11

.Model Wmodel_Trace1284::MIPI_DSI1_DATA2_P W MODELTYPE=RLGC N=2
+ Lo=
+ 3.31623759e-07
+ 2.58042749e-08 3.31623759e-07
+ Co=
+ 1.03563549e-10
+ -2.13865996e-12 1.03563549e-10
+ Ro=
+ 3.96831067e+00
+ 0.00000000e+00 3.96831067e+00
+ Go=
+ 0.00000000e+00
+ -0.00000000e+00 0.00000000e+00
+ Rs=
+ 1.55902417e-03
+ -0.00000000e+00 1.55902417e-03
+ Gd=
+ 2.03963380e-11
+ -0.00000000e+00 2.03963380e-11

.Model Wmodel_Trace1286::MIPI_DSI1_DATA2_P W MODELTYPE=RLGC N=1
+ Lo=
+ 3.32029740e-07
+ Co=
+ 1.03489020e-10
+ Ro=
+ 3.96831067e+00
+ Go=
+ 0.00000000e+00
+ Rs=
+ 1.55902417e-03
+ Gd=
+ 2.04067990e-11

.Model Wmodel_Trace1290::MIPI_DSI1_DATA2_P W MODELTYPE=RLGC N=1
+ Lo=
+ 8.24350330e-07
+ Co=
+ 3.67394016e-11
+ Ro=
+ 3.96831067e+00
+ Go=
+ 0.00000000e+00
+ Rs=
+ 1.02517469e-03
+ Gd=
+ 6.50321060e-12

.Model Wmodel_Trace1294::MIPI_DSI1_DATA2_P W MODELTYPE=RLGC N=1
+ Lo=
+ 3.32029740e-07
+ Co=
+ 1.03489020e-10
+ Ro=
+ 3.96831067e+00
+ Go=
+ 0.00000000e+00
+ Rs=
+ 1.55902417e-03
+ Gd=
+ 2.04067990e-11

.Model Wmodel_Trace1295::MIPI_DSI1_DATA2_P W MODELTYPE=RLGC N=1
+ Lo=
+ 8.24350330e-07
+ Co=
+ 3.67394016e-11
+ Ro=
+ 3.96831067e+00
+ Go=
+ 0.00000000e+00
+ Rs=
+ 1.02517469e-03
+ Gd=
+ 6.50321060e-12

.Model Wmodel_Trace1299::MIPI_DSI1_DATA2_P W MODELTYPE=RLGC N=1
+ Lo=
+ 3.32029740e-07
+ Co=
+ 1.03489020e-10
+ Ro=
+ 3.96831067e+00
+ Go=
+ 0.00000000e+00
+ Rs=
+ 1.55902417e-03
+ Gd=
+ 2.04067990e-11

.Model Wmodel_Trace1304#BP0::MIPI_DSI1_DATA2_P W MODELTYPE=RLGC N=1
+ Lo=
+ 3.32029740e-07
+ Co=
+ 1.03489020e-10
+ Ro=
+ 3.96831067e+00
+ Go=
+ 0.00000000e+00
+ Rs=
+ 1.55902417e-03
+ Gd=
+ 2.04067990e-11

.Model Wmodel_Trace1304::MIPI_DSI1_DATA2_P W MODELTYPE=RLGC N=1
+ Lo=
+ 8.24350330e-07
+ Co=
+ 3.67394016e-11
+ Ro=
+ 3.96831067e+00
+ Go=
+ 0.00000000e+00
+ Rs=
+ 1.02517469e-03
+ Gd=
+ 6.50321060e-12

.Model Wmodel_Trace1306::MIPI_DSI1_DATA2_P W MODELTYPE=RLGC N=1
+ Lo=
+ 3.32029740e-07
+ Co=
+ 1.03489020e-10
+ Ro=
+ 3.96831067e+00
+ Go=
+ 0.00000000e+00
+ Rs=
+ 1.55902417e-03
+ Gd=
+ 2.04067990e-11

.Model Wmodel_Trace1315::MIPI_DSI1_DATA2_P W MODELTYPE=RLGC N=1
+ Lo=
+ 3.32029740e-07
+ Co=
+ 1.03489020e-10
+ Ro=
+ 3.96831067e+00
+ Go=
+ 0.00000000e+00
+ Rs=
+ 1.55902417e-03
+ Gd=
+ 2.04067990e-11

.Model Wmodel_Trace1326::MIPI_DSI1_DATA2_P W MODELTYPE=RLGC N=1
+ Lo=
+ 3.32029740e-07
+ Co=
+ 1.03489020e-10
+ Ro=
+ 3.96831067e+00
+ Go=
+ 0.00000000e+00
+ Rs=
+ 1.55902417e-03
+ Gd=
+ 2.04067990e-11

.Model Wmodel_Trace1328::MIPI_DSI1_DATA2_P W MODELTYPE=RLGC N=3
+ Lo=
+ 3.31602095e-07
+ 2.57166043e-08 3.31207254e-07
+ 6.87193900e-09 2.60668532e-08 3.31589293e-07
+ Co=
+ 1.03565750e-10
+ -2.12639058e-12 1.03640109e-10
+ -3.51342814e-13 -2.16891570e-12 1.03568627e-10
+ Ro=
+ 3.96831067e+00
+ 0.00000000e+00 3.96831067e+00
+ 0.00000000e+00 0.00000000e+00 3.96831067e+00
+ Go=
+ 0.00000000e+00
+ -0.00000000e+00 0.00000000e+00
+ -0.00000000e+00 -0.00000000e+00 0.00000000e+00
+ Rs=
+ 1.55902417e-03
+ -0.00000000e+00 1.55902417e-03
+ -0.00000000e+00 -0.00000000e+00 1.55902417e-03
+ Gd=
+ 2.03959968e-11
+ -0.00000000e+00 2.03858142e-11
+ -0.00000000e+00 -0.00000000e+00 2.03957015e-11

.Model Wmodel_Trace1332::MIPI_DSI1_DATA2_P W MODELTYPE=RLGC N=1
+ Lo=
+ 3.32029740e-07
+ Co=
+ 1.03489020e-10
+ Ro=
+ 3.96831067e+00
+ Go=
+ 0.00000000e+00
+ Rs=
+ 1.55902417e-03
+ Gd=
+ 2.04067990e-11

.Model Wmodel_Trace1334::MIPI_DSI1_DATA2_P W MODELTYPE=RLGC N=1
+ Lo=
+ 3.32029740e-07
+ Co=
+ 1.03489020e-10
+ Ro=
+ 3.96831067e+00
+ Go=
+ 0.00000000e+00
+ Rs=
+ 1.55902417e-03
+ Gd=
+ 2.04067990e-11

.Model Wmodel_Trace1334_Auto_1443::MIPI_DSI1_DATA2_P W MODELTYPE=RLGC N=2
+ Lo=
+ 3.30725731e-07
+ 4.24795967e-08 3.30725731e-07
+ Co=
+ 1.03815237e-10
+ -4.57491037e-12 1.03815237e-10
+ Ro=
+ 3.96831067e+00
+ 0.00000000e+00 3.96831067e+00
+ Go=
+ 0.00000000e+00
+ -0.00000000e+00 0.00000000e+00
+ Rs=
+ 1.55902417e-03
+ -0.00000000e+00 1.55902417e-03
+ Gd=
+ 2.03825377e-11
+ -1.80568253e-13 2.03825377e-11

.Model Wmodel_Trace1334_Auto_1445::MIPI_DSI1_DATA2_P W MODELTYPE=RLGC N=1
+ Lo=
+ 3.32029740e-07
+ Co=
+ 1.03489020e-10
+ Ro=
+ 3.96831067e+00
+ Go=
+ 0.00000000e+00
+ Rs=
+ 1.55902417e-03
+ Gd=
+ 2.04067990e-11

.Model Wmodel_Trace1336::MIPI_DSI1_DATA2_P W MODELTYPE=RLGC N=1
+ Lo=
+ 3.32029740e-07
+ Co=
+ 1.03489020e-10
+ Ro=
+ 3.96831067e+00
+ Go=
+ 0.00000000e+00
+ Rs=
+ 1.55902417e-03
+ Gd=
+ 2.04067990e-11

.Model Wmodel_Trace1338::MIPI_DSI1_DATA2_P W MODELTYPE=RLGC N=1
+ Lo=
+ 3.32029740e-07
+ Co=
+ 1.03489020e-10
+ Ro=
+ 3.96831067e+00
+ Go=
+ 0.00000000e+00
+ Rs=
+ 1.55902417e-03
+ Gd=
+ 2.04067990e-11

.Model Wmodel_Trace1338_Auto_1433::MIPI_DSI1_DATA2_P W MODELTYPE=RLGC N=2
+ Lo=
+ 3.30763257e-07
+ 4.19593268e-08 3.30763257e-07
+ Co=
+ 1.03803079e-10
+ -4.48673319e-12 1.03803079e-10
+ Ro=
+ 3.96831067e+00
+ 0.00000000e+00 3.96831067e+00
+ Go=
+ 0.00000000e+00
+ -0.00000000e+00 0.00000000e+00
+ Rs=
+ 1.55902417e-03
+ -0.00000000e+00 1.55902417e-03
+ Gd=
+ 2.03828468e-11
+ -1.71711693e-13 2.03828468e-11

.Model Wmodel_Trace1338_Auto_1434::MIPI_DSI1_DATA2_P W MODELTYPE=RLGC N=1
+ Lo=
+ 3.32029740e-07
+ Co=
+ 1.03489020e-10
+ Ro=
+ 3.96831067e+00
+ Go=
+ 0.00000000e+00
+ Rs=
+ 1.55902417e-03
+ Gd=
+ 2.04067990e-11

.Model Wmodel_Trace1338_Auto_1435::MIPI_DSI1_DATA2_P W MODELTYPE=RLGC N=2
+ Lo=
+ 3.30763257e-07
+ 4.19593268e-08 3.30763257e-07
+ Co=
+ 1.03803079e-10
+ -4.48673319e-12 1.03803079e-10
+ Ro=
+ 3.96831067e+00
+ 0.00000000e+00 3.96831067e+00
+ Go=
+ 0.00000000e+00
+ -0.00000000e+00 0.00000000e+00
+ Rs=
+ 1.55902417e-03
+ -0.00000000e+00 1.55902417e-03
+ Gd=
+ 2.03828468e-11
+ -1.71711693e-13 2.03828468e-11

.Model Wmodel_Trace1338_Auto_1436::MIPI_DSI1_DATA2_P W MODELTYPE=RLGC N=1
+ Lo=
+ 3.32029740e-07
+ Co=
+ 1.03489020e-10
+ Ro=
+ 3.96831067e+00
+ Go=
+ 0.00000000e+00
+ Rs=
+ 1.55902417e-03
+ Gd=
+ 2.04067990e-11

.Model Wmodel_Trace1338_Auto_1437::MIPI_DSI1_DATA2_P W MODELTYPE=RLGC N=2
+ Lo=
+ 3.30763257e-07
+ 4.19593268e-08 3.30763257e-07
+ Co=
+ 1.03803079e-10
+ -4.48673319e-12 1.03803079e-10
+ Ro=
+ 3.96831067e+00
+ 0.00000000e+00 3.96831067e+00
+ Go=
+ 0.00000000e+00
+ -0.00000000e+00 0.00000000e+00
+ Rs=
+ 1.55902417e-03
+ -0.00000000e+00 1.55902417e-03
+ Gd=
+ 2.03828468e-11
+ -1.71711693e-13 2.03828468e-11

.Model Wmodel_Trace1338_Auto_1438::MIPI_DSI1_DATA2_P W MODELTYPE=RLGC N=1
+ Lo=
+ 3.32029740e-07
+ Co=
+ 1.03489020e-10
+ Ro=
+ 3.96831067e+00
+ Go=
+ 0.00000000e+00
+ Rs=
+ 1.55902417e-03
+ Gd=
+ 2.04067990e-11

.Model Wmodel_Trace1338_Auto_1439::MIPI_DSI1_DATA2_P W MODELTYPE=RLGC N=2
+ Lo=
+ 3.30763257e-07
+ 4.19593268e-08 3.30763257e-07
+ Co=
+ 1.03803079e-10
+ -4.48673319e-12 1.03803079e-10
+ Ro=
+ 3.96831067e+00
+ 0.00000000e+00 3.96831067e+00
+ Go=
+ 0.00000000e+00
+ -0.00000000e+00 0.00000000e+00
+ Rs=
+ 1.55902417e-03
+ -0.00000000e+00 1.55902417e-03
+ Gd=
+ 2.03828468e-11
+ -1.71711693e-13 2.03828468e-11

.Model Wmodel_Trace1338_Auto_1440::MIPI_DSI1_DATA2_P W MODELTYPE=RLGC N=1
+ Lo=
+ 3.32029740e-07
+ Co=
+ 1.03489020e-10
+ Ro=
+ 3.96831067e+00
+ Go=
+ 0.00000000e+00
+ Rs=
+ 1.55902417e-03
+ Gd=
+ 2.04067990e-11

.Model Wmodel_Trace1338_Auto_1441::MIPI_DSI1_DATA2_P W MODELTYPE=RLGC N=2
+ Lo=
+ 3.30747262e-07
+ 4.21821942e-08 3.30747262e-07
+ Co=
+ 1.03808247e-10
+ -4.52441508e-12 1.03808247e-10
+ Ro=
+ 3.96831067e+00
+ 0.00000000e+00 3.96831067e+00
+ Go=
+ 0.00000000e+00
+ -0.00000000e+00 0.00000000e+00
+ Rs=
+ 1.55902417e-03
+ -0.00000000e+00 1.55902417e-03
+ Gd=
+ 2.03827124e-11
+ -1.75484369e-13 2.03827124e-11

.Model Wmodel_Trace1338_Auto_1442::MIPI_DSI1_DATA2_P W MODELTYPE=RLGC N=1
+ Lo=
+ 3.32029740e-07
+ Co=
+ 1.03489020e-10
+ Ro=
+ 3.96831067e+00
+ Go=
+ 0.00000000e+00
+ Rs=
+ 1.55902417e-03
+ Gd=
+ 2.04067990e-11

.Model Wmodel_Trace1338_Auto_1449::MIPI_DSI1_DATA2_P W MODELTYPE=RLGC N=2
+ Lo=
+ 3.30713716e-07
+ 4.26442705e-08 3.30713716e-07
+ Co=
+ 1.03819154e-10
+ -4.60297355e-12 1.03819154e-10
+ Ro=
+ 3.96831067e+00
+ 0.00000000e+00 3.96831067e+00
+ Go=
+ 0.00000000e+00
+ -0.00000000e+00 0.00000000e+00
+ Rs=
+ 1.55902417e-03
+ -0.00000000e+00 1.55902417e-03
+ Gd=
+ 2.03824433e-11
+ -1.83407506e-13 2.03824433e-11

.Model Wmodel_Trace1340::MIPI_DSI1_DATA2_P W MODELTYPE=RLGC N=1
+ Lo=
+ 3.32029740e-07
+ Co=
+ 1.03489020e-10
+ Ro=
+ 3.96831067e+00
+ Go=
+ 0.00000000e+00
+ Rs=
+ 1.55902417e-03
+ Gd=
+ 2.04067990e-11

.Model Wmodel_Trace1342::MIPI_DSI1_DATA2_P W MODELTYPE=RLGC N=2
+ Lo=
+ 3.30740451e-07
+ 4.22765921e-08 3.30740451e-07
+ Co=
+ 1.03810454e-10
+ -4.54041656e-12 1.03810454e-10
+ Ro=
+ 3.96831067e+00
+ 0.00000000e+00 3.96831067e+00
+ Go=
+ 0.00000000e+00
+ -0.00000000e+00 0.00000000e+00
+ Rs=
+ 1.55902417e-03
+ -0.00000000e+00 1.55902417e-03
+ Gd=
+ 2.03826564e-11
+ -1.77091913e-13 2.03826564e-11

.Model Wmodel_Trace1342_Auto_1447::MIPI_DSI1_DATA2_P W MODELTYPE=RLGC N=1
+ Lo=
+ 3.32029740e-07
+ Co=
+ 1.03489020e-10
+ Ro=
+ 3.96831067e+00
+ Go=
+ 0.00000000e+00
+ Rs=
+ 1.55902417e-03
+ Gd=
+ 2.04067990e-11

.Model Wmodel_Trace1343::MIPI_DSI1_DATA2_P W MODELTYPE=RLGC N=1
+ Lo=
+ 3.32029740e-07
+ Co=
+ 1.03489020e-10
+ Ro=
+ 3.96831067e+00
+ Go=
+ 0.00000000e+00
+ Rs=
+ 1.55902417e-03
+ Gd=
+ 2.04067990e-11

.Model Wmodel_Trace1343_Auto_1688::MIPI_DSI1_DATA2_P W MODELTYPE=RLGC N=2
+ Lo=
+ 3.30748904e-07
+ 4.21593990e-08 3.30748904e-07
+ Co=
+ 1.03807716e-10
+ -4.52055469e-12 1.03807716e-10
+ Ro=
+ 3.96831067e+00
+ 0.00000000e+00 3.96831067e+00
+ Go=
+ 0.00000000e+00
+ -0.00000000e+00 0.00000000e+00
+ Rs=
+ 1.55902417e-03
+ -0.00000000e+00 1.55902417e-03
+ Gd=
+ 2.03827260e-11
+ -1.75097034e-13 2.03827260e-11

.Model Wmodel_Trace1344::MIPI_DSI1_DATA2_P W MODELTYPE=RLGC N=1
+ Lo=
+ 3.32029740e-07
+ Co=
+ 1.03489020e-10
+ Ro=
+ 3.96831067e+00
+ Go=
+ 0.00000000e+00
+ Rs=
+ 1.55902417e-03
+ Gd=
+ 2.04067990e-11

.Model Wmodel_Trace1345::MIPI_DSI1_DATA2_P W MODELTYPE=RLGC N=2
+ Lo=
+ 3.31483106e-07
+ 2.93373896e-08 3.31483106e-07
+ Co=
+ 1.03596552e-10
+ -2.58469842e-12 1.03596552e-10
+ Ro=
+ 3.96831067e+00
+ 0.00000000e+00 3.96831067e+00
+ Go=
+ 0.00000000e+00
+ -0.00000000e+00 0.00000000e+00
+ Rs=
+ 1.55902417e-03
+ -0.00000000e+00 1.55902417e-03
+ Gd=
+ 2.03932515e-11
+ -1.21548448e-14 2.03932515e-11

.Model Wmodel_Trace3906::N2739972 W MODELTYPE=RLGC N=1
+ Lo=
+ 2.65390220e-07
+ Co=
+ 1.37513602e-10
+ Ro=
+ 2.42066951e+00
+ Go=
+ 0.00000000e+00
+ Rs=
+ 1.18814509e-03
+ Gd=
+ 2.80154174e-11

.Model Wmodel_Trace3907_Auto_769::N2739972 W MODELTYPE=RLGC N=1
+ Lo=
+ 2.65390220e-07
+ Co=
+ 1.37513602e-10
+ Ro=
+ 2.42066951e+00
+ Go=
+ 0.00000000e+00
+ Rs=
+ 1.18814509e-03
+ Gd=
+ 2.80154174e-11

.Model Wmodel_Trace3907_Auto_778::N2739972 W MODELTYPE=RLGC N=6
+ Lo=
+ 2.63691472e-07
+ 4.55452496e-08 3.27265953e-07
+ 1.21353808e-08 4.10048123e-08 3.27974157e-07
+ 5.87493437e-09 1.38453732e-08 5.58302436e-08 3.28566464e-07
+ 2.88367643e-09 5.11134008e-09 1.19216768e-08 3.26056802e-08 3.30325189e-07
+ 1.76898390e-09 2.71800835e-09 4.89407545e-09 9.32055402e-09 3.59051652e-08 3.31081791e-07
+ Co=
+ 1.38292694e-10
+ -7.02617163e-12 1.04511210e-10
+ -6.72239945e-13 -4.39884987e-12 1.04607122e-10
+ -3.07463047e-13 -5.66598630e-13 -7.14167249e-12 1.04444999e-10
+ -1.65504603e-13 -2.19122102e-13 -5.09610970e-13 -3.03798765e-12 1.03846742e-10
+ -1.04872187e-13 -1.18543885e-13 -2.06011497e-13 -4.32953378e-13 -3.52194517e-12 1.03692773e-10
+ Ro=
+ 2.42066951e+00
+ 0.00000000e+00 3.96831067e+00
+ 0.00000000e+00 0.00000000e+00 3.96831067e+00
+ 0.00000000e+00 0.00000000e+00 0.00000000e+00 3.96831067e+00
+ 0.00000000e+00 0.00000000e+00 0.00000000e+00 0.00000000e+00 3.96831067e+00
+ 0.00000000e+00 0.00000000e+00 0.00000000e+00 0.00000000e+00 0.00000000e+00 3.96831067e+00
+ Go=
+ 0.00000000e+00
+ -0.00000000e+00 0.00000000e+00
+ -0.00000000e+00 -0.00000000e+00 0.00000000e+00
+ -0.00000000e+00 -0.00000000e+00 -0.00000000e+00 0.00000000e+00
+ -0.00000000e+00 -0.00000000e+00 -0.00000000e+00 -0.00000000e+00 0.00000000e+00
+ -0.00000000e+00 -0.00000000e+00 -0.00000000e+00 -0.00000000e+00 -0.00000000e+00 0.00000000e+00
+ Rs=
+ 1.18814509e-03
+ -0.00000000e+00 1.55902417e-03
+ -0.00000000e+00 -0.00000000e+00 1.55902417e-03
+ -0.00000000e+00 -0.00000000e+00 -0.00000000e+00 1.55902417e-03
+ -0.00000000e+00 -0.00000000e+00 -0.00000000e+00 -0.00000000e+00 1.55902417e-03
+ -0.00000000e+00 -0.00000000e+00 -0.00000000e+00 -0.00000000e+00 -0.00000000e+00 1.55902417e-03
+ Gd=
+ 2.79835439e-11
+ -4.29129167e-13 2.03574834e-11
+ -0.00000000e+00 -1.87446064e-13 2.03594582e-11
+ -0.00000000e+00 -0.00000000e+00 -4.88798022e-13 2.03660550e-11
+ -0.00000000e+00 -0.00000000e+00 -0.00000000e+00 -5.88210874e-14 2.03699315e-11
+ -0.00000000e+00 -0.00000000e+00 -0.00000000e+00 -0.00000000e+00 -8.76962874e-14 2.03865045e-11

.Model Wmodel_Trace3907_Auto_813::N2739972 W MODELTYPE=RLGC N=7
+ Lo=
+ 2.63690720e-07
+ 4.55441333e-08 3.27264284e-07
+ 1.21334668e-08 4.10019120e-08 3.27969002e-07
+ 5.87147029e-09 1.38400246e-08 5.58204208e-08 3.28546899e-07
+ 2.87134190e-09 5.09121074e-09 1.18812261e-08 3.25156986e-08 3.29805577e-07
+ 1.82103954e-09 2.82971603e-09 5.19719596e-09 1.01776383e-08 4.24270129e-08 3.29346029e-07
+ 1.26717364e-09 1.80917975e-09 2.88613559e-09 4.68689587e-09 1.19946242e-08 4.19667570e-08 3.30648787e-07
+ Co=
+ 1.38292803e-10
+ -7.02605501e-12 1.04511335e-10
+ -6.72051627e-13 -4.39864754e-12 1.04607455e-10
+ -3.07106398e-13 -5.66207217e-13 -7.14102427e-12 1.04446296e-10
+ -1.63111004e-13 -2.16381551e-13 -5.04706997e-13 -3.02698807e-12 1.03989436e-10
+ -1.02125508e-13 -1.16967378e-13 -2.07344344e-13 -4.51218327e-13 -4.59001004e-12 1.04148103e-10
+ -7.44673206e-14 -7.77694170e-14 -1.19835097e-13 -2.04994397e-13 -5.33968421e-13 -4.50222170e-12 1.03817629e-10
+ Ro=
+ 2.42066951e+00
+ 0.00000000e+00 3.96831067e+00
+ 0.00000000e+00 0.00000000e+00 3.96831067e+00
+ 0.00000000e+00 0.00000000e+00 0.00000000e+00 3.96831067e+00
+ 0.00000000e+00 0.00000000e+00 0.00000000e+00 0.00000000e+00 3.96831067e+00
+ 0.00000000e+00 0.00000000e+00 0.00000000e+00 0.00000000e+00 0.00000000e+00 3.96831067e+00
+ 0.00000000e+00 0.00000000e+00 0.00000000e+00 0.00000000e+00 0.00000000e+00 0.00000000e+00 3.96831067e+00
+ Go=
+ 0.00000000e+00
+ -0.00000000e+00 0.00000000e+00
+ -0.00000000e+00 -0.00000000e+00 0.00000000e+00
+ -0.00000000e+00 -0.00000000e+00 -0.00000000e+00 0.00000000e+00
+ -0.00000000e+00 -0.00000000e+00 -0.00000000e+00 -0.00000000e+00 0.00000000e+00
+ -0.00000000e+00 -0.00000000e+00 -0.00000000e+00 -0.00000000e+00 -0.00000000e+00 0.00000000e+00
+ -0.00000000e+00 -0.00000000e+00 -0.00000000e+00 -0.00000000e+00 -0.00000000e+00 -0.00000000e+00 0.00000000e+00
+ Rs=
+ 1.18814509e-03
+ -0.00000000e+00 1.55902417e-03
+ -0.00000000e+00 -0.00000000e+00 1.55902417e-03
+ -0.00000000e+00 -0.00000000e+00 -0.00000000e+00 1.55902417e-03
+ -0.00000000e+00 -0.00000000e+00 -0.00000000e+00 -0.00000000e+00 1.55902417e-03
+ -0.00000000e+00 -0.00000000e+00 -0.00000000e+00 -0.00000000e+00 -0.00000000e+00 1.55902417e-03
+ -0.00000000e+00 -0.00000000e+00 -0.00000000e+00 -0.00000000e+00 -0.00000000e+00 -0.00000000e+00 1.55902417e-03
+ Gd=
+ 2.79835302e-11
+ -4.29143564e-13 2.03574683e-11
+ -0.00000000e+00 -1.87470342e-13 2.03594198e-11
+ -0.00000000e+00 -0.00000000e+00 -4.88873036e-13 2.03659039e-11
+ -0.00000000e+00 -0.00000000e+00 -0.00000000e+00 -5.98216995e-14 2.03645393e-11
+ -0.00000000e+00 -0.00000000e+00 -0.00000000e+00 -0.00000000e+00 -1.96366468e-13 2.03585501e-11
+ -0.00000000e+00 -0.00000000e+00 -0.00000000e+00 -0.00000000e+00 -0.00000000e+00 -1.82229153e-13 2.03817461e-11

.Model Wmodel_Trace3908::N2739972 W MODELTYPE=RLGC N=1
+ Lo=
+ 3.58484574e-07
+ Co=
+ 9.37055974e-11
+ Ro=
+ 4.84133902e+00
+ Go=
+ 0.00000000e+00
+ Rs=
+ 1.72420198e-03
+ Gd=
+ 1.82370500e-11

.Model Wmodel_Trace551::MIPI_DSI1_CLK_N W MODELTYPE=RLGC N=1
+ Lo=
+ 3.32029740e-07
+ Co=
+ 1.03489020e-10
+ Ro=
+ 3.96831067e+00
+ Go=
+ 0.00000000e+00
+ Rs=
+ 1.55902417e-03
+ Gd=
+ 2.04067990e-11

.Model Wmodel_Trace553::MIPI_DSI1_CLK_N W MODELTYPE=RLGC N=2
+ Lo=
+ 3.30769440e-07
+ 4.18727259e-08 3.30769440e-07
+ Co=
+ 1.03801088e-10
+ -4.47212757e-12 1.03801088e-10
+ Ro=
+ 3.96831067e+00
+ 0.00000000e+00 3.96831067e+00
+ Go=
+ 0.00000000e+00
+ -0.00000000e+00 0.00000000e+00
+ Rs=
+ 1.55902417e-03
+ -0.00000000e+00 1.55902417e-03
+ Gd=
+ 2.03828998e-11
+ -1.70254314e-13 2.03828998e-11

.Model Wmodel_Trace555::MIPI_DSI1_CLK_N W MODELTYPE=RLGC N=1
+ Lo=
+ 3.32029740e-07
+ Co=
+ 1.03489020e-10
+ Ro=
+ 3.96831067e+00
+ Go=
+ 0.00000000e+00
+ Rs=
+ 1.55902417e-03
+ Gd=
+ 2.04067990e-11

.Model Wmodel_Trace557::MIPI_DSI1_CLK_N W MODELTYPE=RLGC N=1
+ Lo=
+ 3.32029740e-07
+ Co=
+ 1.03489020e-10
+ Ro=
+ 3.96831067e+00
+ Go=
+ 0.00000000e+00
+ Rs=
+ 1.55902417e-03
+ Gd=
+ 2.04067990e-11

.Model Wmodel_Trace557_Auto_147::MIPI_DSI1_CLK_N W MODELTYPE=RLGC N=2
+ Lo=
+ 3.30706772e-07
+ 4.27390456e-08 3.30706772e-07
+ Co=
+ 1.03821424e-10
+ -4.61915822e-12 1.03821424e-10
+ Ro=
+ 3.96831067e+00
+ 0.00000000e+00 3.96831067e+00
+ Go=
+ 0.00000000e+00
+ -0.00000000e+00 0.00000000e+00
+ Rs=
+ 1.55902417e-03
+ -0.00000000e+00 1.55902417e-03
+ Gd=
+ 2.03823897e-11
+ -1.85049413e-13 2.03823897e-11

.Model Wmodel_Trace557_Auto_148::MIPI_DSI1_CLK_N W MODELTYPE=RLGC N=1
+ Lo=
+ 3.32029740e-07
+ Co=
+ 1.03489020e-10
+ Ro=
+ 3.96831067e+00
+ Go=
+ 0.00000000e+00
+ Rs=
+ 1.55902417e-03
+ Gd=
+ 2.04067990e-11

.Model Wmodel_Trace559::MIPI_DSI1_CLK_N W MODELTYPE=RLGC N=1
+ Lo=
+ 3.32029740e-07
+ Co=
+ 1.03489020e-10
+ Ro=
+ 3.96831067e+00
+ Go=
+ 0.00000000e+00
+ Rs=
+ 1.55902417e-03
+ Gd=
+ 2.04067990e-11

.Model Wmodel_Trace561::MIPI_DSI1_CLK_N W MODELTYPE=RLGC N=1
+ Lo=
+ 3.32029740e-07
+ Co=
+ 1.03489020e-10
+ Ro=
+ 3.96831067e+00
+ Go=
+ 0.00000000e+00
+ Rs=
+ 1.55902417e-03
+ Gd=
+ 2.04067990e-11

.Model Wmodel_Trace561_Auto_145::MIPI_DSI1_CLK_N W MODELTYPE=RLGC N=2
+ Lo=
+ 3.30740670e-07
+ 4.22735563e-08 3.30740670e-07
+ Co=
+ 1.03810383e-10
+ -4.53990158e-12 1.03810383e-10
+ Ro=
+ 3.96831067e+00
+ 0.00000000e+00 3.96831067e+00
+ Go=
+ 0.00000000e+00
+ -0.00000000e+00 0.00000000e+00
+ Rs=
+ 1.55902417e-03
+ -0.00000000e+00 1.55902417e-03
+ Gd=
+ 2.03826582e-11
+ -1.77040127e-13 2.03826582e-11

.Model Wmodel_Trace562::MIPI_DSI1_CLK_N W MODELTYPE=RLGC N=1
+ Lo=
+ 3.32029740e-07
+ Co=
+ 1.03489020e-10
+ Ro=
+ 3.96831067e+00
+ Go=
+ 0.00000000e+00
+ Rs=
+ 1.55902417e-03
+ Gd=
+ 2.04067990e-11

.Model Wmodel_Trace573::MIPI_DSI1_CLK_N W MODELTYPE=RLGC N=1
+ Lo=
+ 3.32029740e-07
+ Co=
+ 1.03489020e-10
+ Ro=
+ 3.96831067e+00
+ Go=
+ 0.00000000e+00
+ Rs=
+ 1.55902417e-03
+ Gd=
+ 2.04067990e-11

.Model Wmodel_Trace574_Auto_170::MIPI_DSI1_CLK_N W MODELTYPE=RLGC N=1
+ Lo=
+ 3.32029740e-07
+ Co=
+ 1.03489020e-10
+ Ro=
+ 3.96831067e+00
+ Go=
+ 0.00000000e+00
+ Rs=
+ 1.55902417e-03
+ Gd=
+ 2.04067990e-11

.Model Wmodel_Trace575::MIPI_DSI1_CLK_N W MODELTYPE=RLGC N=1
+ Lo=
+ 3.32029740e-07
+ Co=
+ 1.03489020e-10
+ Ro=
+ 3.96831067e+00
+ Go=
+ 0.00000000e+00
+ Rs=
+ 1.55902417e-03
+ Gd=
+ 2.04067990e-11

.Model Wmodel_Trace584::MIPI_DSI1_CLK_N W MODELTYPE=RLGC N=1
+ Lo=
+ 3.32029740e-07
+ Co=
+ 1.03489020e-10
+ Ro=
+ 3.96831067e+00
+ Go=
+ 0.00000000e+00
+ Rs=
+ 1.55902417e-03
+ Gd=
+ 2.04067990e-11

.Model Wmodel_Trace586::MIPI_DSI1_CLK_N W MODELTYPE=RLGC N=1
+ Lo=
+ 3.32029740e-07
+ Co=
+ 1.03489020e-10
+ Ro=
+ 3.96831067e+00
+ Go=
+ 0.00000000e+00
+ Rs=
+ 1.55902417e-03
+ Gd=
+ 2.04067990e-11

.Model Wmodel_Trace586_Auto_187::MIPI_DSI1_CLK_N W MODELTYPE=RLGC N=3
+ Lo=
+ 3.30051172e-07
+ 4.92950423e-08 3.28847903e-07
+ 1.32455837e-08 4.22520519e-08 3.30622881e-07
+ Co=
+ 1.04024123e-10
+ -5.81762043e-12 1.04340865e-10
+ -5.80432408e-13 -4.55150632e-12 1.03825169e-10
+ Ro=
+ 3.96831067e+00
+ 0.00000000e+00 3.96831067e+00
+ 0.00000000e+00 0.00000000e+00 3.96831067e+00
+ Go=
+ 0.00000000e+00
+ -0.00000000e+00 0.00000000e+00
+ -0.00000000e+00 -0.00000000e+00 0.00000000e+00
+ Rs=
+ 1.55902417e-03
+ -0.00000000e+00 1.55902417e-03
+ -0.00000000e+00 -0.00000000e+00 1.55902417e-03
+ Gd=
+ 2.03795689e-11
+ -3.23777119e-13 2.03574155e-11
+ -0.00000000e+00 -1.88634064e-13 2.03816676e-11

.Model Wmodel_Trace588::MIPI_DSI1_CLK_N W MODELTYPE=RLGC N=1
+ Lo=
+ 3.32029740e-07
+ Co=
+ 1.03489020e-10
+ Ro=
+ 3.96831067e+00
+ Go=
+ 0.00000000e+00
+ Rs=
+ 1.55902417e-03
+ Gd=
+ 2.04067990e-11

.Model Wmodel_Trace598::MIPI_DSI1_CLK_N W MODELTYPE=RLGC N=1
+ Lo=
+ 3.32029740e-07
+ Co=
+ 1.03489020e-10
+ Ro=
+ 3.96831067e+00
+ Go=
+ 0.00000000e+00
+ Rs=
+ 1.55902417e-03
+ Gd=
+ 2.04067990e-11

.Model Wmodel_Trace598_Auto_167::MIPI_DSI1_CLK_N W MODELTYPE=RLGC N=6
+ Lo=
+ 3.30643730e-07
+ 4.17347530e-08 3.28872565e-07
+ 1.28495267e-08 4.79049181e-08 3.28801546e-07
+ 5.43634676e-09 1.27297133e-08 4.13976409e-08 3.29106843e-07
+ 3.02468757e-09 5.54225181e-09 1.21232839e-08 4.42253444e-08 3.29186411e-07
+ 1.91391537e-09 3.02619920e-09 5.26690611e-09 1.22563423e-08 4.18033931e-08 3.30652097e-07
+ Co=
+ 1.03814916e-10
+ -4.46678859e-12 1.04302266e-10
+ -5.54751008e-13 -5.58065521e-12 1.04307032e-10
+ -2.32517705e-13 -5.37879616e-13 -4.42489599e-12 1.04199512e-10
+ -1.29862699e-13 -2.24678137e-13 -5.18671026e-13 -4.90929349e-12 1.04194653e-10
+ -8.65451449e-14 -1.28525421e-13 -2.24836630e-13 -5.37684382e-13 -4.47622161e-12 1.03814850e-10
+ Ro=
+ 3.96831067e+00
+ 0.00000000e+00 3.96831067e+00
+ 0.00000000e+00 0.00000000e+00 3.96831067e+00
+ 0.00000000e+00 0.00000000e+00 0.00000000e+00 3.96831067e+00
+ 0.00000000e+00 0.00000000e+00 0.00000000e+00 0.00000000e+00 3.96831067e+00
+ 0.00000000e+00 0.00000000e+00 0.00000000e+00 0.00000000e+00 0.00000000e+00 3.96831067e+00
+ Go=
+ 0.00000000e+00
+ -0.00000000e+00 0.00000000e+00
+ -0.00000000e+00 -0.00000000e+00 0.00000000e+00
+ -0.00000000e+00 -0.00000000e+00 -0.00000000e+00 0.00000000e+00
+ -0.00000000e+00 -0.00000000e+00 -0.00000000e+00 -0.00000000e+00 0.00000000e+00
+ -0.00000000e+00 -0.00000000e+00 -0.00000000e+00 -0.00000000e+00 -0.00000000e+00 0.00000000e+00
+ Rs=
+ 1.55902417e-03
+ -0.00000000e+00 1.55902417e-03
+ -0.00000000e+00 -0.00000000e+00 1.55902417e-03
+ -0.00000000e+00 -0.00000000e+00 -0.00000000e+00 1.55902417e-03
+ -0.00000000e+00 -0.00000000e+00 -0.00000000e+00 -0.00000000e+00 1.55902417e-03
+ -0.00000000e+00 -0.00000000e+00 -0.00000000e+00 -0.00000000e+00 -0.00000000e+00 1.55902417e-03
+ Gd=
+ 2.03817632e-11
+ -1.80464915e-13 2.03568153e-11
+ -0.00000000e+00 -3.06021805e-13 2.03562205e-11
+ -0.00000000e+00 -0.00000000e+00 -1.85001901e-13 2.03570175e-11
+ -0.00000000e+00 -0.00000000e+00 -0.00000000e+00 -2.32276952e-13 2.03576494e-11
+ -0.00000000e+00 -0.00000000e+00 -0.00000000e+00 -0.00000000e+00 -1.80262204e-13 2.03817954e-11

.Model Wmodel_Trace598_Auto_179::MIPI_DSI1_CLK_N W MODELTYPE=RLGC N=1
+ Lo=
+ 3.32029740e-07
+ Co=
+ 1.03489020e-10
+ Ro=
+ 3.96831067e+00
+ Go=
+ 0.00000000e+00
+ Rs=
+ 1.55902417e-03
+ Gd=
+ 2.04067990e-11

.Model Wmodel_Trace598_Auto_194::MIPI_DSI1_CLK_N W MODELTYPE=RLGC N=6
+ Lo=
+ 3.30643488e-07
+ 4.17342228e-08 3.28871397e-07
+ 1.28480676e-08 4.79016496e-08 3.28792142e-07
+ 5.42901949e-09 1.27125481e-08 4.13454113e-08 3.28791072e-07
+ 3.09565423e-09 5.72450160e-09 1.27143327e-08 4.79128662e-08 3.28868743e-07
+ 1.94832121e-09 3.09618013e-09 5.43074504e-09 1.28542441e-08 4.17566342e-08 3.30641747e-07
+ Co=
+ 1.03814929e-10
+ -4.46676253e-12 1.04302318e-10
+ -5.54673983e-13 -5.58050682e-12 1.04307444e-10
+ -2.31190316e-13 -5.35416287e-13 -4.41839199e-12 1.04307814e-10
+ -1.31245594e-13 -2.28669485e-13 -5.35458306e-13 -5.58262847e-12 1.04303209e-10
+ -8.79903859e-14 -1.31271440e-13 -2.31244883e-13 -5.54857649e-13 -4.47057981e-12 1.03815463e-10
+ Ro=
+ 3.96831067e+00
+ 0.00000000e+00 3.96831067e+00
+ 0.00000000e+00 0.00000000e+00 3.96831067e+00
+ 0.00000000e+00 0.00000000e+00 0.00000000e+00 3.96831067e+00
+ 0.00000000e+00 0.00000000e+00 0.00000000e+00 0.00000000e+00 3.96831067e+00
+ 0.00000000e+00 0.00000000e+00 0.00000000e+00 0.00000000e+00 0.00000000e+00 3.96831067e+00
+ Go=
+ 0.00000000e+00
+ -0.00000000e+00 0.00000000e+00
+ -0.00000000e+00 -0.00000000e+00 0.00000000e+00
+ -0.00000000e+00 -0.00000000e+00 -0.00000000e+00 0.00000000e+00
+ -0.00000000e+00 -0.00000000e+00 -0.00000000e+00 -0.00000000e+00 0.00000000e+00
+ -0.00000000e+00 -0.00000000e+00 -0.00000000e+00 -0.00000000e+00 -0.00000000e+00 0.00000000e+00
+ Rs=
+ 1.55902417e-03
+ -0.00000000e+00 1.55902417e-03
+ -0.00000000e+00 -0.00000000e+00 1.55902417e-03
+ -0.00000000e+00 -0.00000000e+00 -0.00000000e+00 1.55902417e-03
+ -0.00000000e+00 -0.00000000e+00 -0.00000000e+00 -0.00000000e+00 1.55902417e-03
+ -0.00000000e+00 -0.00000000e+00 -0.00000000e+00 -0.00000000e+00 -0.00000000e+00 1.55902417e-03
+ Gd=
+ 2.03817622e-11
+ -1.80467059e-13 2.03568111e-11
+ -0.00000000e+00 -3.06034371e-13 2.03561844e-11
+ -0.00000000e+00 -0.00000000e+00 -1.85444628e-13 2.03561837e-11
+ -0.00000000e+00 -0.00000000e+00 -0.00000000e+00 -3.06281413e-13 2.03567981e-11
+ -0.00000000e+00 -0.00000000e+00 -0.00000000e+00 -0.00000000e+00 -1.80855679e-13 2.03817481e-11

.Model Wmodel_Trace598_Auto_202::MIPI_DSI1_CLK_N W MODELTYPE=RLGC N=6
+ Lo=
+ 3.30643914e-07
+ 4.17351503e-08 3.28873429e-07
+ 1.28505999e-08 4.79072865e-08 3.28808209e-07
+ 5.44156052e-09 1.27417077e-08 4.14332260e-08 3.29313107e-07
+ 2.97007364e-09 5.40378599e-09 1.16824989e-08 4.15656710e-08 3.29393731e-07
+ 1.88716826e-09 2.97220243e-09 5.14192557e-09 1.18113728e-08 4.18397736e-08 3.30659094e-07
+ Co=
+ 1.03814906e-10
+ -4.46680932e-12 1.04302226e-10
+ -5.54810905e-13 -5.58076943e-12 1.04306720e-10
+ -2.33452881e-13 -5.39603087e-13 -4.42937352e-12 1.04132784e-10
+ -1.28670321e-13 -2.21384454e-13 -5.05412495e-13 -4.44647477e-12 1.04127848e-10
+ -8.54187394e-14 -1.26400447e-13 -2.19923440e-13 -5.24142468e-13 -4.48088024e-12 1.03814502e-10
+ Ro=
+ 3.96831067e+00
+ 0.00000000e+00 3.96831067e+00
+ 0.00000000e+00 0.00000000e+00 3.96831067e+00
+ 0.00000000e+00 0.00000000e+00 0.00000000e+00 3.96831067e+00
+ 0.00000000e+00 0.00000000e+00 0.00000000e+00 0.00000000e+00 3.96831067e+00
+ 0.00000000e+00 0.00000000e+00 0.00000000e+00 0.00000000e+00 0.00000000e+00 3.96831067e+00
+ Go=
+ 0.00000000e+00
+ -0.00000000e+00 0.00000000e+00
+ -0.00000000e+00 -0.00000000e+00 0.00000000e+00
+ -0.00000000e+00 -0.00000000e+00 -0.00000000e+00 0.00000000e+00
+ -0.00000000e+00 -0.00000000e+00 -0.00000000e+00 -0.00000000e+00 0.00000000e+00
+ -0.00000000e+00 -0.00000000e+00 -0.00000000e+00 -0.00000000e+00 -0.00000000e+00 0.00000000e+00
+ Rs=
+ 1.55902417e-03
+ -0.00000000e+00 1.55902417e-03
+ -0.00000000e+00 -0.00000000e+00 1.55902417e-03
+ -0.00000000e+00 -0.00000000e+00 -0.00000000e+00 1.55902417e-03
+ -0.00000000e+00 -0.00000000e+00 -0.00000000e+00 -0.00000000e+00 1.55902417e-03
+ -0.00000000e+00 -0.00000000e+00 -0.00000000e+00 -0.00000000e+00 -0.00000000e+00 1.55902417e-03
+ Gd=
+ 2.03817642e-11
+ -1.80463098e-13 2.03568188e-11
+ -0.00000000e+00 -3.06011573e-13 2.03562492e-11
+ -0.00000000e+00 -0.00000000e+00 -1.84671880e-13 2.03582988e-11
+ -0.00000000e+00 -0.00000000e+00 -0.00000000e+00 -1.84177656e-13 2.03589413e-11
+ -0.00000000e+00 -0.00000000e+00 -0.00000000e+00 -0.00000000e+00 -1.79904341e-13 2.03818297e-11

.Model Wmodel_Trace598_Auto_205::MIPI_DSI1_CLK_N W MODELTYPE=RLGC N=4
+ Lo=
+ 3.30647936e-07
+ 4.17377146e-08 3.28848843e-07
+ 1.29425005e-08 4.84000301e-08 3.28848843e-07
+ 5.52654106e-09 1.29425005e-08 4.17377146e-08 3.30647936e-07
+ Co=
+ 1.03814504e-10
+ -4.46670159e-12 1.04315738e-10
+ -5.58396158e-13 -5.66916550e-12 1.04315738e-10
+ -2.44056777e-13 -5.58396158e-13 -4.46670159e-12 1.03814504e-10
+ Ro=
+ 3.96831067e+00
+ 0.00000000e+00 3.96831067e+00
+ 0.00000000e+00 0.00000000e+00 3.96831067e+00
+ 0.00000000e+00 0.00000000e+00 0.00000000e+00 3.96831067e+00
+ Go=
+ 0.00000000e+00
+ -0.00000000e+00 0.00000000e+00
+ -0.00000000e+00 -0.00000000e+00 0.00000000e+00
+ -0.00000000e+00 -0.00000000e+00 -0.00000000e+00 0.00000000e+00
+ Rs=
+ 1.55902417e-03
+ -0.00000000e+00 1.55902417e-03
+ -0.00000000e+00 -0.00000000e+00 1.55902417e-03
+ -0.00000000e+00 -0.00000000e+00 -0.00000000e+00 1.55902417e-03
+ Gd=
+ 2.03818222e-11
+ -1.80422025e-13 2.03569600e-11
+ -0.00000000e+00 -3.15398897e-13 2.03569600e-11
+ -0.00000000e+00 -0.00000000e+00 -1.80422025e-13 2.03818222e-11

.Model Wmodel_Trace607::MIPI_DSI1_CLK_N W MODELTYPE=RLGC N=1
+ Lo=
+ 3.32029740e-07
+ Co=
+ 1.03489020e-10
+ Ro=
+ 3.96831067e+00
+ Go=
+ 0.00000000e+00
+ Rs=
+ 1.55902417e-03
+ Gd=
+ 2.04067990e-11

.Model Wmodel_Trace610::MIPI_DSI1_CLK_N W MODELTYPE=RLGC N=1
+ Lo=
+ 3.32029740e-07
+ Co=
+ 1.03489020e-10
+ Ro=
+ 3.96831067e+00
+ Go=
+ 0.00000000e+00
+ Rs=
+ 1.55902417e-03
+ Gd=
+ 2.04067990e-11

.Model Wmodel_Trace610_Auto_176::MIPI_DSI1_CLK_N W MODELTYPE=RLGC N=1
+ Lo=
+ 3.32029740e-07
+ Co=
+ 1.03489020e-10
+ Ro=
+ 3.96831067e+00
+ Go=
+ 0.00000000e+00
+ Rs=
+ 1.55902417e-03
+ Gd=
+ 2.04067990e-11

.Model Wmodel_Trace611::MIPI_DSI1_CLK_N W MODELTYPE=RLGC N=1
+ Lo=
+ 3.32029740e-07
+ Co=
+ 1.03489020e-10
+ Ro=
+ 3.96831067e+00
+ Go=
+ 0.00000000e+00
+ Rs=
+ 1.55902417e-03
+ Gd=
+ 2.04067990e-11

.Model Wmodel_Trace627::MIPI_DSI1_CLK_N W MODELTYPE=RLGC N=2
+ Lo=
+ 3.30715653e-07
+ 4.26177803e-08 3.30715653e-07
+ Co=
+ 1.03818522e-10
+ -4.59845420e-12 1.03818522e-10
+ Ro=
+ 3.96831067e+00
+ 0.00000000e+00 3.96831067e+00
+ Go=
+ 0.00000000e+00
+ -0.00000000e+00 0.00000000e+00
+ Rs=
+ 1.55902417e-03
+ -0.00000000e+00 1.55902417e-03
+ Gd=
+ 2.03824583e-11
+ -1.82949605e-13 2.03824583e-11

.Model Wmodel_Trace627_Auto_384::MIPI_DSI1_CLK_N W MODELTYPE=RLGC N=1
+ Lo=
+ 3.32029740e-07
+ Co=
+ 1.03489020e-10
+ Ro=
+ 3.96831067e+00
+ Go=
+ 0.00000000e+00
+ Rs=
+ 1.55902417e-03
+ Gd=
+ 2.04067990e-11

.Model Wmodel_Trace628_Auto_1004::MIPI_DSI1_CLK_N W MODELTYPE=RLGC N=1
+ Lo=
+ 3.32029740e-07
+ Co=
+ 1.03489020e-10
+ Ro=
+ 3.96831067e+00
+ Go=
+ 0.00000000e+00
+ Rs=
+ 1.55902417e-03
+ Gd=
+ 2.04067990e-11

.Model Wmodel_Trace630::MIPI_DSI1_CLK_N W MODELTYPE=RLGC N=1
+ Lo=
+ 3.32029740e-07
+ Co=
+ 1.03489020e-10
+ Ro=
+ 3.96831067e+00
+ Go=
+ 0.00000000e+00
+ Rs=
+ 1.55902417e-03
+ Gd=
+ 2.04067990e-11

.Model Wmodel_Trace632::MIPI_DSI1_CLK_N W MODELTYPE=RLGC N=1
+ Lo=
+ 3.32029740e-07
+ Co=
+ 1.03489020e-10
+ Ro=
+ 3.96831067e+00
+ Go=
+ 0.00000000e+00
+ Rs=
+ 1.55902417e-03
+ Gd=
+ 2.04067990e-11

.Model Wmodel_Trace632_Auto_1013::MIPI_DSI1_CLK_N W MODELTYPE=RLGC N=2
+ Lo=
+ 3.30739358e-07
+ 4.22917086e-08 3.30739358e-07
+ Co=
+ 1.03810808e-10
+ -4.54298124e-12 1.03810808e-10
+ Ro=
+ 3.96831067e+00
+ 0.00000000e+00 3.96831067e+00
+ Go=
+ 0.00000000e+00
+ -0.00000000e+00 0.00000000e+00
+ Rs=
+ 1.55902417e-03
+ -0.00000000e+00 1.55902417e-03
+ Gd=
+ 2.03826475e-11
+ -1.77349869e-13 2.03826475e-11

.Model Wmodel_Trace633::MIPI_DSI1_CLK_N W MODELTYPE=RLGC N=1
+ Lo=
+ 3.32029740e-07
+ Co=
+ 1.03489020e-10
+ Ro=
+ 3.96831067e+00
+ Go=
+ 0.00000000e+00
+ Rs=
+ 1.55902417e-03
+ Gd=
+ 2.04067990e-11

.Model Wmodel_Trace636::MIPI_DSI1_CLK_N W MODELTYPE=RLGC N=1
+ Lo=
+ 3.32029740e-07
+ Co=
+ 1.03489020e-10
+ Ro=
+ 3.96831067e+00
+ Go=
+ 0.00000000e+00
+ Rs=
+ 1.55902417e-03
+ Gd=
+ 2.04067990e-11

.Model Wmodel_Trace637::MIPI_DSI1_CLK_N W MODELTYPE=RLGC N=1
+ Lo=
+ 3.58484574e-07
+ Co=
+ 9.37055974e-11
+ Ro=
+ 4.84133902e+00
+ Go=
+ 0.00000000e+00
+ Rs=
+ 1.72420198e-03
+ Gd=
+ 1.82370500e-11

.Model Wmodel_Trace638::MIPI_DSI1_CLK_N W MODELTYPE=RLGC N=1
+ Lo=
+ 3.58484574e-07
+ Co=
+ 9.37055974e-11
+ Ro=
+ 4.84133902e+00
+ Go=
+ 0.00000000e+00
+ Rs=
+ 1.72420198e-03
+ Gd=
+ 1.82370500e-11

.Model Wmodel_Trace639::MIPI_DSI1_CLK_N W MODELTYPE=RLGC N=1
+ Lo=
+ 3.32029740e-07
+ Co=
+ 1.03489020e-10
+ Ro=
+ 3.96831067e+00
+ Go=
+ 0.00000000e+00
+ Rs=
+ 1.55902417e-03
+ Gd=
+ 2.04067990e-11

.Model Wmodel_Trace639_Auto_1697::MIPI_DSI1_CLK_N W MODELTYPE=RLGC N=2
+ Lo=
+ 3.30748904e-07
+ 4.21593990e-08 3.30748904e-07
+ Co=
+ 1.03807716e-10
+ -4.52055469e-12 1.03807716e-10
+ Ro=
+ 3.96831067e+00
+ 0.00000000e+00 3.96831067e+00
+ Go=
+ 0.00000000e+00
+ -0.00000000e+00 0.00000000e+00
+ Rs=
+ 1.55902417e-03
+ -0.00000000e+00 1.55902417e-03
+ Gd=
+ 2.03827260e-11
+ -1.75097034e-13 2.03827260e-11

.Model Wmodel_Trace641::MIPI_DSI1_CLK_N W MODELTYPE=RLGC N=1
+ Lo=
+ 3.32029740e-07
+ Co=
+ 1.03489020e-10
+ Ro=
+ 3.96831067e+00
+ Go=
+ 0.00000000e+00
+ Rs=
+ 1.55902417e-03
+ Gd=
+ 2.04067990e-11

.Model Wmodel_Trace643::MIPI_DSI1_CLK_N W MODELTYPE=RLGC N=2
+ Lo=
+ 3.30740259e-07
+ 4.22792495e-08 3.30740259e-07
+ Co=
+ 1.03810516e-10
+ -4.54086737e-12 1.03810516e-10
+ Ro=
+ 3.96831067e+00
+ 0.00000000e+00 3.96831067e+00
+ Go=
+ 0.00000000e+00
+ -0.00000000e+00 0.00000000e+00
+ Rs=
+ 1.55902417e-03
+ -0.00000000e+00 1.55902417e-03
+ Gd=
+ 2.03826548e-11
+ -1.77137250e-13 2.03826548e-11

.Model Wmodel_Trace643_Auto_1699::MIPI_DSI1_CLK_N W MODELTYPE=RLGC N=2
+ Lo=
+ 3.30749128e-07
+ 4.21562848e-08 3.30749128e-07
+ Co=
+ 1.03807643e-10
+ -4.52002742e-12 1.03807643e-10
+ Ro=
+ 3.96831067e+00
+ 0.00000000e+00 3.96831067e+00
+ Go=
+ 0.00000000e+00
+ -0.00000000e+00 0.00000000e+00
+ Rs=
+ 1.55902417e-03
+ -0.00000000e+00 1.55902417e-03
+ Gd=
+ 2.03827279e-11
+ -1.75044145e-13 2.03827279e-11

.Model Wmodel_Trace643_Auto_1700::MIPI_DSI1_CLK_N W MODELTYPE=RLGC N=1
+ Lo=
+ 3.32029740e-07
+ Co=
+ 1.03489020e-10
+ Ro=
+ 3.96831067e+00
+ Go=
+ 0.00000000e+00
+ Rs=
+ 1.55902417e-03
+ Gd=
+ 2.04067990e-11

.Model Wmodel_Trace644::MIPI_DSI1_CLK_N W MODELTYPE=RLGC N=1
+ Lo=
+ 3.32029740e-07
+ Co=
+ 1.03489020e-10
+ Ro=
+ 3.96831067e+00
+ Go=
+ 0.00000000e+00
+ Rs=
+ 1.55902417e-03
+ Gd=
+ 2.04067990e-11

.Model Wmodel_Trace644_Auto_1732::MIPI_DSI1_CLK_N W MODELTYPE=RLGC N=2
+ Lo=
+ 3.30715407e-07
+ 4.26211454e-08 3.30715407e-07
+ Co=
+ 1.03818602e-10
+ -4.59902819e-12 1.03818602e-10
+ Ro=
+ 3.96831067e+00
+ 0.00000000e+00 3.96831067e+00
+ Go=
+ 0.00000000e+00
+ -0.00000000e+00 0.00000000e+00
+ Rs=
+ 1.55902417e-03
+ -0.00000000e+00 1.55902417e-03
+ Gd=
+ 2.03824564e-11
+ -1.83007748e-13 2.03824564e-11

.Model Wmodel_Trace646::MIPI_DSI1_CLK_N W MODELTYPE=RLGC N=1
+ Lo=
+ 3.32029740e-07
+ Co=
+ 1.03489020e-10
+ Ro=
+ 3.96831067e+00
+ Go=
+ 0.00000000e+00
+ Rs=
+ 1.55902417e-03
+ Gd=
+ 2.04067990e-11

.Model Wmodel_Trace648::MIPI_DSI1_CLK_N W MODELTYPE=RLGC N=1
+ Lo=
+ 3.32029740e-07
+ Co=
+ 1.03489020e-10
+ Ro=
+ 3.96831067e+00
+ Go=
+ 0.00000000e+00
+ Rs=
+ 1.55902417e-03
+ Gd=
+ 2.04067990e-11

.Model Wmodel_Trace648_Auto_1729::MIPI_DSI1_CLK_N W MODELTYPE=RLGC N=2
+ Lo=
+ 3.30707272e-07
+ 4.27322266e-08 3.30707272e-07
+ Co=
+ 1.03821260e-10
+ -4.61799294e-12 1.03821260e-10
+ Ro=
+ 3.96831067e+00
+ 0.00000000e+00 3.96831067e+00
+ Go=
+ 0.00000000e+00
+ -0.00000000e+00 0.00000000e+00
+ Rs=
+ 1.55902417e-03
+ -0.00000000e+00 1.55902417e-03
+ Gd=
+ 2.03823935e-11
+ -1.84931089e-13 2.03823935e-11

.Model Wmodel_Trace648_Auto_1730::MIPI_DSI1_CLK_N W MODELTYPE=RLGC N=1
+ Lo=
+ 3.32029740e-07
+ Co=
+ 1.03489020e-10
+ Ro=
+ 3.96831067e+00
+ Go=
+ 0.00000000e+00
+ Rs=
+ 1.55902417e-03
+ Gd=
+ 2.04067990e-11

.Model Wmodel_Trace650::MIPI_DSI1_CLK_N W MODELTYPE=RLGC N=1
+ Lo=
+ 3.32029740e-07
+ Co=
+ 1.03489020e-10
+ Ro=
+ 3.96831067e+00
+ Go=
+ 0.00000000e+00
+ Rs=
+ 1.55902417e-03
+ Gd=
+ 2.04067990e-11

.Model Wmodel_Trace652::MIPI_DSI1_CLK_N W MODELTYPE=RLGC N=1
+ Lo=
+ 3.32029740e-07
+ Co=
+ 1.03489020e-10
+ Ro=
+ 3.96831067e+00
+ Go=
+ 0.00000000e+00
+ Rs=
+ 1.55902417e-03
+ Gd=
+ 2.04067990e-11

.Model Wmodel_Trace652_Auto_1726::MIPI_DSI1_CLK_N W MODELTYPE=RLGC N=2
+ Lo=
+ 3.30748904e-07
+ 4.21593990e-08 3.30748904e-07
+ Co=
+ 1.03807716e-10
+ -4.52055469e-12 1.03807716e-10
+ Ro=
+ 3.96831067e+00
+ 0.00000000e+00 3.96831067e+00
+ Go=
+ 0.00000000e+00
+ -0.00000000e+00 0.00000000e+00
+ Rs=
+ 1.55902417e-03
+ -0.00000000e+00 1.55902417e-03
+ Gd=
+ 2.03827260e-11
+ -1.75097034e-13 2.03827260e-11

.Model Wmodel_Trace652_Auto_1727::MIPI_DSI1_CLK_N W MODELTYPE=RLGC N=1
+ Lo=
+ 3.32029740e-07
+ Co=
+ 1.03489020e-10
+ Ro=
+ 3.96831067e+00
+ Go=
+ 0.00000000e+00
+ Rs=
+ 1.55902417e-03
+ Gd=
+ 2.04067990e-11

.Model Wmodel_Trace654::MIPI_DSI1_CLK_N W MODELTYPE=RLGC N=1
+ Lo=
+ 3.32029740e-07
+ Co=
+ 1.03489020e-10
+ Ro=
+ 3.96831067e+00
+ Go=
+ 0.00000000e+00
+ Rs=
+ 1.55902417e-03
+ Gd=
+ 2.04067990e-11

.Model Wmodel_Trace659::MIPI_DSI1_CLK_P W MODELTYPE=RLGC N=1
+ Lo=
+ 3.32029740e-07
+ Co=
+ 1.03489020e-10
+ Ro=
+ 3.96831067e+00
+ Go=
+ 0.00000000e+00
+ Rs=
+ 1.55902417e-03
+ Gd=
+ 2.04067990e-11

.Model Wmodel_Trace661#BP0::MIPI_DSI1_CLK_P W MODELTYPE=RLGC N=1
+ Lo=
+ 3.32029740e-07
+ Co=
+ 1.03489020e-10
+ Ro=
+ 3.96831067e+00
+ Go=
+ 0.00000000e+00
+ Rs=
+ 1.55902417e-03
+ Gd=
+ 2.04067990e-11

.Model Wmodel_Trace661#BP0_Auto_20::MIPI_DSI1_CLK_P W MODELTYPE=RLGC N=1
+ Lo=
+ 3.32029740e-07
+ Co=
+ 1.03489020e-10
+ Ro=
+ 3.96831067e+00
+ Go=
+ 0.00000000e+00
+ Rs=
+ 1.55902417e-03
+ Gd=
+ 2.04067990e-11

.Model Wmodel_Trace663::MIPI_DSI1_CLK_P W MODELTYPE=RLGC N=1
+ Lo=
+ 3.32029740e-07
+ Co=
+ 1.03489020e-10
+ Ro=
+ 3.96831067e+00
+ Go=
+ 0.00000000e+00
+ Rs=
+ 1.55902417e-03
+ Gd=
+ 2.04067990e-11

.Model Wmodel_Trace665::MIPI_DSI1_CLK_P W MODELTYPE=RLGC N=1
+ Lo=
+ 3.32029740e-07
+ Co=
+ 1.03489020e-10
+ Ro=
+ 3.96831067e+00
+ Go=
+ 0.00000000e+00
+ Rs=
+ 1.55902417e-03
+ Gd=
+ 2.04067990e-11

.Model Wmodel_Trace667::MIPI_DSI1_CLK_P W MODELTYPE=RLGC N=1
+ Lo=
+ 3.32029740e-07
+ Co=
+ 1.03489020e-10
+ Ro=
+ 3.96831067e+00
+ Go=
+ 0.00000000e+00
+ Rs=
+ 1.55902417e-03
+ Gd=
+ 2.04067990e-11

.Model Wmodel_Trace679::MIPI_DSI1_CLK_P W MODELTYPE=RLGC N=1
+ Lo=
+ 3.32029740e-07
+ Co=
+ 1.03489020e-10
+ Ro=
+ 3.96831067e+00
+ Go=
+ 0.00000000e+00
+ Rs=
+ 1.55902417e-03
+ Gd=
+ 2.04067990e-11

.Model Wmodel_Trace681_Auto_198::MIPI_DSI1_CLK_P W MODELTYPE=RLGC N=1
+ Lo=
+ 3.32029740e-07
+ Co=
+ 1.03489020e-10
+ Ro=
+ 3.96831067e+00
+ Go=
+ 0.00000000e+00
+ Rs=
+ 1.55902417e-03
+ Gd=
+ 2.04067990e-11

.Model Wmodel_Trace682::MIPI_DSI1_CLK_P W MODELTYPE=RLGC N=1
+ Lo=
+ 3.32029740e-07
+ Co=
+ 1.03489020e-10
+ Ro=
+ 3.96831067e+00
+ Go=
+ 0.00000000e+00
+ Rs=
+ 1.55902417e-03
+ Gd=
+ 2.04067990e-11

.Model Wmodel_Trace683_Auto_190::MIPI_DSI1_CLK_P W MODELTYPE=RLGC N=1
+ Lo=
+ 3.32029740e-07
+ Co=
+ 1.03489020e-10
+ Ro=
+ 3.96831067e+00
+ Go=
+ 0.00000000e+00
+ Rs=
+ 1.55902417e-03
+ Gd=
+ 2.04067990e-11

.Model Wmodel_Trace683_Auto_196::MIPI_DSI1_CLK_P W MODELTYPE=RLGC N=1
+ Lo=
+ 3.32029740e-07
+ Co=
+ 1.03489020e-10
+ Ro=
+ 3.96831067e+00
+ Go=
+ 0.00000000e+00
+ Rs=
+ 1.55902417e-03
+ Gd=
+ 2.04067990e-11

.Model Wmodel_Trace685::MIPI_DSI1_CLK_P W MODELTYPE=RLGC N=1
+ Lo=
+ 3.32029740e-07
+ Co=
+ 1.03489020e-10
+ Ro=
+ 3.96831067e+00
+ Go=
+ 0.00000000e+00
+ Rs=
+ 1.55902417e-03
+ Gd=
+ 2.04067990e-11

.Model Wmodel_Trace694::MIPI_DSI1_CLK_P W MODELTYPE=RLGC N=1
+ Lo=
+ 3.32029740e-07
+ Co=
+ 1.03489020e-10
+ Ro=
+ 3.96831067e+00
+ Go=
+ 0.00000000e+00
+ Rs=
+ 1.55902417e-03
+ Gd=
+ 2.04067990e-11

.Model Wmodel_Trace694_Auto_184::MIPI_DSI1_CLK_P W MODELTYPE=RLGC N=1
+ Lo=
+ 3.32029740e-07
+ Co=
+ 1.03489020e-10
+ Ro=
+ 3.96831067e+00
+ Go=
+ 0.00000000e+00
+ Rs=
+ 1.55902417e-03
+ Gd=
+ 2.04067990e-11

.Model Wmodel_Trace694_Auto_186::MIPI_DSI1_CLK_P W MODELTYPE=RLGC N=1
+ Lo=
+ 3.32029740e-07
+ Co=
+ 1.03489020e-10
+ Ro=
+ 3.96831067e+00
+ Go=
+ 0.00000000e+00
+ Rs=
+ 1.55902417e-03
+ Gd=
+ 2.04067990e-11

.Model Wmodel_Trace704::MIPI_DSI1_CLK_P W MODELTYPE=RLGC N=1
+ Lo=
+ 3.32029740e-07
+ Co=
+ 1.03489020e-10
+ Ro=
+ 3.96831067e+00
+ Go=
+ 0.00000000e+00
+ Rs=
+ 1.55902417e-03
+ Gd=
+ 2.04067990e-11

.Model Wmodel_Trace706::MIPI_DSI1_CLK_P W MODELTYPE=RLGC N=1
+ Lo=
+ 3.32029740e-07
+ Co=
+ 1.03489020e-10
+ Ro=
+ 3.96831067e+00
+ Go=
+ 0.00000000e+00
+ Rs=
+ 1.55902417e-03
+ Gd=
+ 2.04067990e-11

.Model Wmodel_Trace706_Auto_181::MIPI_DSI1_CLK_P W MODELTYPE=RLGC N=1
+ Lo=
+ 3.32029740e-07
+ Co=
+ 1.03489020e-10
+ Ro=
+ 3.96831067e+00
+ Go=
+ 0.00000000e+00
+ Rs=
+ 1.55902417e-03
+ Gd=
+ 2.04067990e-11

.Model Wmodel_Trace706_Auto_185::MIPI_DSI1_CLK_P W MODELTYPE=RLGC N=1
+ Lo=
+ 3.32029740e-07
+ Co=
+ 1.03489020e-10
+ Ro=
+ 3.96831067e+00
+ Go=
+ 0.00000000e+00
+ Rs=
+ 1.55902417e-03
+ Gd=
+ 2.04067990e-11

.Model Wmodel_Trace708::MIPI_DSI1_CLK_P W MODELTYPE=RLGC N=1
+ Lo=
+ 3.32029740e-07
+ Co=
+ 1.03489020e-10
+ Ro=
+ 3.96831067e+00
+ Go=
+ 0.00000000e+00
+ Rs=
+ 1.55902417e-03
+ Gd=
+ 2.04067990e-11

.Model Wmodel_Trace716::MIPI_DSI1_CLK_P W MODELTYPE=RLGC N=1
+ Lo=
+ 3.32029740e-07
+ Co=
+ 1.03489020e-10
+ Ro=
+ 3.96831067e+00
+ Go=
+ 0.00000000e+00
+ Rs=
+ 1.55902417e-03
+ Gd=
+ 2.04067990e-11

.Model Wmodel_Trace716_Auto_173::MIPI_DSI1_CLK_P W MODELTYPE=RLGC N=1
+ Lo=
+ 3.32029740e-07
+ Co=
+ 1.03489020e-10
+ Ro=
+ 3.96831067e+00
+ Go=
+ 0.00000000e+00
+ Rs=
+ 1.55902417e-03
+ Gd=
+ 2.04067990e-11

.Model Wmodel_Trace722::MIPI_DSI1_CLK_P W MODELTYPE=RLGC N=1
+ Lo=
+ 3.32029740e-07
+ Co=
+ 1.03489020e-10
+ Ro=
+ 3.96831067e+00
+ Go=
+ 0.00000000e+00
+ Rs=
+ 1.55902417e-03
+ Gd=
+ 2.04067990e-11

.Model Wmodel_Trace727::MIPI_DSI1_CLK_P W MODELTYPE=RLGC N=1
+ Lo=
+ 3.32029740e-07
+ Co=
+ 1.03489020e-10
+ Ro=
+ 3.96831067e+00
+ Go=
+ 0.00000000e+00
+ Rs=
+ 1.55902417e-03
+ Gd=
+ 2.04067990e-11

.Model Wmodel_Trace730::MIPI_DSI1_CLK_P W MODELTYPE=RLGC N=1
+ Lo=
+ 3.32029740e-07
+ Co=
+ 1.03489020e-10
+ Ro=
+ 3.96831067e+00
+ Go=
+ 0.00000000e+00
+ Rs=
+ 1.55902417e-03
+ Gd=
+ 2.04067990e-11

.Model Wmodel_Trace730_Auto_171::MIPI_DSI1_CLK_P W MODELTYPE=RLGC N=6
+ Lo=
+ 3.30417960e-07
+ 4.48485237e-08 3.29111064e-07
+ 1.23844637e-08 4.19819328e-08 3.28778137e-07
+ 5.62321834e-09 1.27916594e-08 4.76029131e-08 3.28780877e-07
+ 3.04371176e-09 5.42411780e-09 1.27621001e-08 4.18460794e-08 3.28928444e-07
+ 1.97965903e-09 3.09118235e-09 5.73400163e-09 1.27444903e-08 4.71766225e-08 3.30219130e-07
+ Co=
+ 1.03891563e-10
+ -5.00528026e-12 1.04217041e-10
+ -5.38446258e-13 -4.52278497e-12 1.04312320e-10
+ -2.33585482e-13 -5.39397853e-13 -5.52850529e-12 1.04310025e-10
+ -1.29432597e-13 -2.23812455e-13 -5.37272871e-13 -4.50077341e-12 1.04281142e-10
+ -8.74219256e-14 -1.30812518e-13 -2.36014625e-13 -5.48879882e-13 -5.42694510e-12 1.03959064e-10
+ Ro=
+ 3.96831067e+00
+ 0.00000000e+00 3.96831067e+00
+ 0.00000000e+00 0.00000000e+00 3.96831067e+00
+ 0.00000000e+00 0.00000000e+00 0.00000000e+00 3.96831067e+00
+ 0.00000000e+00 0.00000000e+00 0.00000000e+00 0.00000000e+00 3.96831067e+00
+ 0.00000000e+00 0.00000000e+00 0.00000000e+00 0.00000000e+00 0.00000000e+00 3.96831067e+00
+ Go=
+ 0.00000000e+00
+ -0.00000000e+00 0.00000000e+00
+ -0.00000000e+00 -0.00000000e+00 0.00000000e+00
+ -0.00000000e+00 -0.00000000e+00 -0.00000000e+00 0.00000000e+00
+ -0.00000000e+00 -0.00000000e+00 -0.00000000e+00 -0.00000000e+00 0.00000000e+00
+ -0.00000000e+00 -0.00000000e+00 -0.00000000e+00 -0.00000000e+00 -0.00000000e+00 0.00000000e+00
+ Rs=
+ 1.55902417e-03
+ -0.00000000e+00 1.55902417e-03
+ -0.00000000e+00 -0.00000000e+00 1.55902417e-03
+ -0.00000000e+00 -0.00000000e+00 -0.00000000e+00 1.55902417e-03
+ -0.00000000e+00 -0.00000000e+00 -0.00000000e+00 -0.00000000e+00 1.55902417e-03
+ -0.00000000e+00 -0.00000000e+00 -0.00000000e+00 -0.00000000e+00 -0.00000000e+00 1.55902417e-03
+ Gd=
+ 2.03802658e-11
+ -2.34600465e-13 2.03572003e-11
+ -0.00000000e+00 -1.94627398e-13 2.03559136e-11
+ -0.00000000e+00 -0.00000000e+00 -3.00903715e-13 2.03559507e-11
+ -0.00000000e+00 -0.00000000e+00 -0.00000000e+00 -1.93054198e-13 2.03566797e-11
+ -0.00000000e+00 -0.00000000e+00 -0.00000000e+00 -0.00000000e+00 -2.80513517e-13 2.03795608e-11

.Model Wmodel_Trace730_Auto_177::MIPI_DSI1_CLK_P W MODELTYPE=RLGC N=1
+ Lo=
+ 3.32029740e-07
+ Co=
+ 1.03489020e-10
+ Ro=
+ 3.96831067e+00
+ Go=
+ 0.00000000e+00
+ Rs=
+ 1.55902417e-03
+ Gd=
+ 2.04067990e-11

.Model Wmodel_Trace733::MIPI_DSI1_CLK_P W MODELTYPE=RLGC N=1
+ Lo=
+ 3.32029740e-07
+ Co=
+ 1.03489020e-10
+ Ro=
+ 3.96831067e+00
+ Go=
+ 0.00000000e+00
+ Rs=
+ 1.55902417e-03
+ Gd=
+ 2.04067990e-11

.Model Wmodel_Trace735::MIPI_DSI1_CLK_P W MODELTYPE=RLGC N=1
+ Lo=
+ 3.32029740e-07
+ Co=
+ 1.03489020e-10
+ Ro=
+ 3.96831067e+00
+ Go=
+ 0.00000000e+00
+ Rs=
+ 1.55902417e-03
+ Gd=
+ 2.04067990e-11

.Model Wmodel_Trace738::MIPI_DSI1_CLK_P W MODELTYPE=RLGC N=1
+ Lo=
+ 3.32029740e-07
+ Co=
+ 1.03489020e-10
+ Ro=
+ 3.96831067e+00
+ Go=
+ 0.00000000e+00
+ Rs=
+ 1.55902417e-03
+ Gd=
+ 2.04067990e-11

.Model Wmodel_Trace742::MIPI_DSI1_CLK_P W MODELTYPE=RLGC N=1
+ Lo=
+ 3.32029740e-07
+ Co=
+ 1.03489020e-10
+ Ro=
+ 3.96831067e+00
+ Go=
+ 0.00000000e+00
+ Rs=
+ 1.55902417e-03
+ Gd=
+ 2.04067990e-11

.Model Wmodel_Trace745::MIPI_DSI1_CLK_P W MODELTYPE=RLGC N=1
+ Lo=
+ 3.58484574e-07
+ Co=
+ 9.37055974e-11
+ Ro=
+ 4.84133902e+00
+ Go=
+ 0.00000000e+00
+ Rs=
+ 1.72420198e-03
+ Gd=
+ 1.82370500e-11

.Model Wmodel_Trace745_Auto_633::MIPI_DSI1_CLK_P W MODELTYPE=RLGC N=7
+ Lo=
+ 3.57494302e-07
+ 4.10402500e-08 3.56548241e-07
+ 1.17998558e-08 4.18279984e-08 3.56857229e-07
+ 4.69599615e-09 1.01228569e-08 3.21748407e-08 3.56030463e-07
+ 2.90287041e-09 5.19619135e-09 1.17020836e-08 5.43699067e-08 3.55669158e-07
+ 1.84444398e-09 2.88049664e-09 5.13698651e-09 1.36527430e-08 4.06890922e-08 3.56514109e-07
+ 1.29252742e-09 1.85440958e-09 2.90007911e-09 5.79576171e-09 1.17263153e-08 4.19174910e-08 3.57443783e-07
+ Co=
+ 9.39183739e-11
+ -3.52378382e-12 9.41357354e-11
+ -4.62415627e-13 -3.63284273e-12 9.40384196e-11
+ -1.78123511e-13 -3.92848060e-13 -2.41572498e-12 9.43111752e-11
+ -1.04995210e-13 -1.82713129e-13 -4.40506259e-13 -5.51324069e-12 9.44115980e-11
+ -6.92827280e-14 -1.04707437e-13 -1.92021401e-13 -5.03222651e-13 -3.47826672e-12 9.41369796e-11
+ -5.03564362e-14 -6.95366579e-14 -1.10477437e-13 -2.09105444e-13 -4.51483643e-13 -3.64358603e-12 9.39323151e-11
+ Ro=
+ 4.84133902e+00
+ 0.00000000e+00 4.84133902e+00
+ 0.00000000e+00 0.00000000e+00 4.84133902e+00
+ 0.00000000e+00 0.00000000e+00 0.00000000e+00 4.84133902e+00
+ 0.00000000e+00 0.00000000e+00 0.00000000e+00 0.00000000e+00 4.84133902e+00
+ 0.00000000e+00 0.00000000e+00 0.00000000e+00 0.00000000e+00 0.00000000e+00 4.84133902e+00
+ 0.00000000e+00 0.00000000e+00 0.00000000e+00 0.00000000e+00 0.00000000e+00 0.00000000e+00 4.84133902e+00
+ Go=
+ 0.00000000e+00
+ -0.00000000e+00 0.00000000e+00
+ -0.00000000e+00 -0.00000000e+00 0.00000000e+00
+ -0.00000000e+00 -0.00000000e+00 -0.00000000e+00 0.00000000e+00
+ -0.00000000e+00 -0.00000000e+00 -0.00000000e+00 -0.00000000e+00 0.00000000e+00
+ -0.00000000e+00 -0.00000000e+00 -0.00000000e+00 -0.00000000e+00 -0.00000000e+00 0.00000000e+00
+ -0.00000000e+00 -0.00000000e+00 -0.00000000e+00 -0.00000000e+00 -0.00000000e+00 -0.00000000e+00 0.00000000e+00
+ Rs=
+ 1.72420198e-03
+ -0.00000000e+00 1.72420198e-03
+ -0.00000000e+00 -0.00000000e+00 1.72420198e-03
+ -0.00000000e+00 -0.00000000e+00 -0.00000000e+00 1.72420198e-03
+ -0.00000000e+00 -0.00000000e+00 -0.00000000e+00 -0.00000000e+00 1.72420198e-03
+ -0.00000000e+00 -0.00000000e+00 -0.00000000e+00 -0.00000000e+00 -0.00000000e+00 1.72420198e-03
+ -0.00000000e+00 -0.00000000e+00 -0.00000000e+00 -0.00000000e+00 -0.00000000e+00 -0.00000000e+00 1.72420198e-03
+ Gd=
+ 1.82170329e-11
+ -1.06701382e-13 1.81981073e-11
+ -0.00000000e+00 -1.20526297e-13 1.82035078e-11
+ -0.00000000e+00 -0.00000000e+00 -2.61810466e-14 1.81990971e-11
+ -0.00000000e+00 -0.00000000e+00 -0.00000000e+00 -3.18883673e-13 1.81932912e-11
+ -0.00000000e+00 -0.00000000e+00 -0.00000000e+00 -0.00000000e+00 -1.11468605e-13 1.81979250e-11
+ -0.00000000e+00 -0.00000000e+00 -0.00000000e+00 -0.00000000e+00 -0.00000000e+00 -1.17617340e-13 1.82164231e-11

.Model Wmodel_Trace748::MIPI_DSI1_CLK_P W MODELTYPE=RLGC N=1
+ Lo=
+ 3.32029740e-07
+ Co=
+ 1.03489020e-10
+ Ro=
+ 3.96831067e+00
+ Go=
+ 0.00000000e+00
+ Rs=
+ 1.55902417e-03
+ Gd=
+ 2.04067990e-11

.Model Wmodel_Trace751::MIPI_DSI1_CLK_P W MODELTYPE=RLGC N=1
+ Lo=
+ 3.32029740e-07
+ Co=
+ 1.03489020e-10
+ Ro=
+ 3.96831067e+00
+ Go=
+ 0.00000000e+00
+ Rs=
+ 1.55902417e-03
+ Gd=
+ 2.04067990e-11

.Model Wmodel_Trace752::MIPI_DSI1_CLK_P W MODELTYPE=RLGC N=1
+ Lo=
+ 3.32029740e-07
+ Co=
+ 1.03489020e-10
+ Ro=
+ 3.96831067e+00
+ Go=
+ 0.00000000e+00
+ Rs=
+ 1.55902417e-03
+ Gd=
+ 2.04067990e-11

.Model Wmodel_Trace755::MIPI_DSI1_CLK_P W MODELTYPE=RLGC N=1
+ Lo=
+ 3.32029740e-07
+ Co=
+ 1.03489020e-10
+ Ro=
+ 3.96831067e+00
+ Go=
+ 0.00000000e+00
+ Rs=
+ 1.55902417e-03
+ Gd=
+ 2.04067990e-11

.Model Wmodel_Trace755_Auto_1733::MIPI_DSI1_CLK_P W MODELTYPE=RLGC N=1
+ Lo=
+ 3.32029740e-07
+ Co=
+ 1.03489020e-10
+ Ro=
+ 3.96831067e+00
+ Go=
+ 0.00000000e+00
+ Rs=
+ 1.55902417e-03
+ Gd=
+ 2.04067990e-11

.Model Wmodel_Trace757::MIPI_DSI1_CLK_P W MODELTYPE=RLGC N=1
+ Lo=
+ 3.32029740e-07
+ Co=
+ 1.03489020e-10
+ Ro=
+ 3.96831067e+00
+ Go=
+ 0.00000000e+00
+ Rs=
+ 1.55902417e-03
+ Gd=
+ 2.04067990e-11

.Model Wmodel_Trace759::MIPI_DSI1_CLK_P W MODELTYPE=RLGC N=1
+ Lo=
+ 3.32029740e-07
+ Co=
+ 1.03489020e-10
+ Ro=
+ 3.96831067e+00
+ Go=
+ 0.00000000e+00
+ Rs=
+ 1.55902417e-03
+ Gd=
+ 2.04067990e-11

.Model Wmodel_Trace761::MIPI_DSI1_CLK_P W MODELTYPE=RLGC N=1
+ Lo=
+ 3.32029740e-07
+ Co=
+ 1.03489020e-10
+ Ro=
+ 3.96831067e+00
+ Go=
+ 0.00000000e+00
+ Rs=
+ 1.55902417e-03
+ Gd=
+ 2.04067990e-11

.Model Wmodel_Trace767::MIPI_DSI1_CLK_P W MODELTYPE=RLGC N=1
+ Lo=
+ 3.32029740e-07
+ Co=
+ 1.03489020e-10
+ Ro=
+ 3.96831067e+00
+ Go=
+ 0.00000000e+00
+ Rs=
+ 1.55902417e-03
+ Gd=
+ 2.04067990e-11

.Model Wmodel_Trace769::MIPI_DSI1_CLK_P W MODELTYPE=RLGC N=2
+ Lo=
+ 3.30751819e-07
+ 4.21188650e-08 3.30751819e-07
+ Co=
+ 1.03806772e-10
+ -4.51369374e-12 1.03806772e-10
+ Ro=
+ 3.96831067e+00
+ 0.00000000e+00 3.96831067e+00
+ Go=
+ 0.00000000e+00
+ -0.00000000e+00 0.00000000e+00
+ Rs=
+ 1.55902417e-03
+ -0.00000000e+00 1.55902417e-03
+ Gd=
+ 2.03827503e-11
+ -1.74409105e-13 2.03827503e-11

.Model Wmodel_Trace769_Auto_1833::MIPI_DSI1_CLK_P W MODELTYPE=RLGC N=1
+ Lo=
+ 3.32029740e-07
+ Co=
+ 1.03489020e-10
+ Ro=
+ 3.96831067e+00
+ Go=
+ 0.00000000e+00
+ Rs=
+ 1.55902417e-03
+ Gd=
+ 2.04067990e-11

.Model Wmodel_Trace778::MIPI_DSI1_CLK_P W MODELTYPE=RLGC N=1
+ Lo=
+ 3.32029740e-07
+ Co=
+ 1.03489020e-10
+ Ro=
+ 3.96831067e+00
+ Go=
+ 0.00000000e+00
+ Rs=
+ 1.55902417e-03
+ Gd=
+ 2.04067990e-11

.Model Wmodel_Trace792::MIPI_DSI1_CLK_P W MODELTYPE=RLGC N=1
+ Lo=
+ 3.32029740e-07
+ Co=
+ 1.03489020e-10
+ Ro=
+ 3.96831067e+00
+ Go=
+ 0.00000000e+00
+ Rs=
+ 1.55902417e-03
+ Gd=
+ 2.04067990e-11

.Model Wmodel_Trace797::MIPI_DSI1_DATA3_N W MODELTYPE=RLGC N=1
+ Lo=
+ 3.58484574e-07
+ Co=
+ 9.37055974e-11
+ Ro=
+ 4.84133902e+00
+ Go=
+ 0.00000000e+00
+ Rs=
+ 1.72420198e-03
+ Gd=
+ 1.82370500e-11

.Model Wmodel_Trace799::MIPI_DSI1_DATA3_N W MODELTYPE=RLGC N=1
+ Lo=
+ 3.58484574e-07
+ Co=
+ 9.37055974e-11
+ Ro=
+ 4.84133902e+00
+ Go=
+ 0.00000000e+00
+ Rs=
+ 1.72420198e-03
+ Gd=
+ 1.82370500e-11

.Model Wmodel_Trace801::MIPI_DSI1_DATA3_N W MODELTYPE=RLGC N=1
+ Lo=
+ 3.32029740e-07
+ Co=
+ 1.03489020e-10
+ Ro=
+ 3.96831067e+00
+ Go=
+ 0.00000000e+00
+ Rs=
+ 1.55902417e-03
+ Gd=
+ 2.04067990e-11

.Model Wmodel_Trace802::MIPI_DSI1_DATA3_N W MODELTYPE=RLGC N=2
+ Lo=
+ 3.28940573e-07
+ 4.41450904e-08 2.63931874e-07
+ Co=
+ 1.04110286e-10
+ -6.64964160e-12 1.38192864e-10
+ Ro=
+ 3.96831067e+00
+ 0.00000000e+00 2.42066951e+00
+ Go=
+ 0.00000000e+00
+ -0.00000000e+00 0.00000000e+00
+ Rs=
+ 1.55902417e-03
+ -0.00000000e+00 1.18814509e-03
+ Gd=
+ 2.03799112e-11
+ -3.72683237e-13 2.79842286e-11

.Model Wmodel_Trace803::MIPI_DSI1_DATA3_N W MODELTYPE=RLGC N=1
+ Lo=
+ 3.32029740e-07
+ Co=
+ 1.03489020e-10
+ Ro=
+ 3.96831067e+00
+ Go=
+ 0.00000000e+00
+ Rs=
+ 1.55902417e-03
+ Gd=
+ 2.04067990e-11

.Model Wmodel_Trace803_Auto_1002::MIPI_DSI1_DATA3_N W MODELTYPE=RLGC N=1
+ Lo=
+ 3.32029740e-07
+ Co=
+ 1.03489020e-10
+ Ro=
+ 3.96831067e+00
+ Go=
+ 0.00000000e+00
+ Rs=
+ 1.55902417e-03
+ Gd=
+ 2.04067990e-11

.Model Wmodel_Trace805::MIPI_DSI1_DATA3_N W MODELTYPE=RLGC N=1
+ Lo=
+ 3.32029740e-07
+ Co=
+ 1.03489020e-10
+ Ro=
+ 3.96831067e+00
+ Go=
+ 0.00000000e+00
+ Rs=
+ 1.55902417e-03
+ Gd=
+ 2.04067990e-11

.Model Wmodel_Trace807::MIPI_DSI1_DATA3_N W MODELTYPE=RLGC N=2
+ Lo=
+ 3.30748904e-07
+ 4.21593990e-08 3.30748904e-07
+ Co=
+ 1.03807716e-10
+ -4.52055469e-12 1.03807716e-10
+ Ro=
+ 3.96831067e+00
+ 0.00000000e+00 3.96831067e+00
+ Go=
+ 0.00000000e+00
+ -0.00000000e+00 0.00000000e+00
+ Rs=
+ 1.55902417e-03
+ -0.00000000e+00 1.55902417e-03
+ Gd=
+ 2.03827260e-11
+ -1.75097034e-13 2.03827260e-11

.Model Wmodel_Trace807_Auto_1007::MIPI_DSI1_DATA3_N W MODELTYPE=RLGC N=4
+ Lo=
+ 3.30700915e-07
+ 4.20133183e-08 3.30263004e-07
+ 9.01776030e-09 2.66330713e-08 3.30229710e-07
+ 4.36591807e-09 9.07108408e-09 4.24801578e-08 3.30666489e-07
+ Co=
+ 1.03811815e-10
+ -4.50277622e-12 1.03893881e-10
+ -4.25248654e-13 -2.23086414e-12 1.03904830e-10
+ -1.96404380e-13 -4.27202568e-13 -4.58219019e-12 1.03822868e-10
+ Ro=
+ 3.96831067e+00
+ 0.00000000e+00 3.96831067e+00
+ 0.00000000e+00 0.00000000e+00 3.96831067e+00
+ 0.00000000e+00 0.00000000e+00 0.00000000e+00 3.96831067e+00
+ Go=
+ 0.00000000e+00
+ -0.00000000e+00 0.00000000e+00
+ -0.00000000e+00 -0.00000000e+00 0.00000000e+00
+ -0.00000000e+00 -0.00000000e+00 -0.00000000e+00 0.00000000e+00
+ Rs=
+ 1.55902417e-03
+ -0.00000000e+00 1.55902417e-03
+ -0.00000000e+00 -0.00000000e+00 1.55902417e-03
+ -0.00000000e+00 -0.00000000e+00 -0.00000000e+00 1.55902417e-03
+ Gd=
+ 2.03821315e-11
+ -1.77635831e-13 2.03712905e-11
+ -0.00000000e+00 -2.18704736e-15 2.03710299e-11
+ -0.00000000e+00 -0.00000000e+00 -1.85653519e-13 2.03818552e-11

.Model Wmodel_Trace807_Auto_1010::MIPI_DSI1_DATA3_N W MODELTYPE=RLGC N=3
+ Lo=
+ 3.30707778e-07
+ 4.20251813e-08 3.30275816e-07
+ 9.24783624e-09 2.75212672e-08 3.31509040e-07
+ Co=
+ 1.03811214e-10
+ -4.50349125e-12 1.03896773e-10
+ -4.44546253e-13 -2.34637264e-12 1.03584016e-10
+ Ro=
+ 3.96831067e+00
+ 0.00000000e+00 3.96831067e+00
+ 0.00000000e+00 0.00000000e+00 3.96831067e+00
+ Go=
+ 0.00000000e+00
+ -0.00000000e+00 0.00000000e+00
+ -0.00000000e+00 -0.00000000e+00 0.00000000e+00
+ Rs=
+ 1.55902417e-03
+ -0.00000000e+00 1.55902417e-03
+ -0.00000000e+00 -0.00000000e+00 1.55902417e-03
+ Gd=
+ 2.03822159e-11
+ -1.77519062e-13 2.03711651e-11
+ -0.00000000e+00 -3.44290742e-15 2.03941739e-11

.Model Wmodel_Trace807_Auto_1011::MIPI_DSI1_DATA3_N W MODELTYPE=RLGC N=2
+ Lo=
+ 3.30740688e-07
+ 4.22733071e-08 3.30740688e-07
+ Co=
+ 1.03810377e-10
+ -4.53985931e-12 1.03810377e-10
+ Ro=
+ 3.96831067e+00
+ 0.00000000e+00 3.96831067e+00
+ Go=
+ 0.00000000e+00
+ -0.00000000e+00 0.00000000e+00
+ Rs=
+ 1.55902417e-03
+ -0.00000000e+00 1.55902417e-03
+ Gd=
+ 2.03826583e-11
+ -1.77035876e-13 2.03826583e-11

.Model Wmodel_Trace807_Auto_1012::MIPI_DSI1_DATA3_N W MODELTYPE=RLGC N=1
+ Lo=
+ 3.32029740e-07
+ Co=
+ 1.03489020e-10
+ Ro=
+ 3.96831067e+00
+ Go=
+ 0.00000000e+00
+ Rs=
+ 1.55902417e-03
+ Gd=
+ 2.04067990e-11

.Model Wmodel_Trace809::MIPI_DSI1_DATA3_N W MODELTYPE=RLGC N=1
+ Lo=
+ 3.32029740e-07
+ Co=
+ 1.03489020e-10
+ Ro=
+ 3.96831067e+00
+ Go=
+ 0.00000000e+00
+ Rs=
+ 1.55902417e-03
+ Gd=
+ 2.04067990e-11

.Model Wmodel_Trace811::MIPI_DSI1_DATA3_N W MODELTYPE=RLGC N=1
+ Lo=
+ 3.32029740e-07
+ Co=
+ 1.03489020e-10
+ Ro=
+ 3.96831067e+00
+ Go=
+ 0.00000000e+00
+ Rs=
+ 1.55902417e-03
+ Gd=
+ 2.04067990e-11

.Model Wmodel_Trace815::MIPI_DSI1_DATA3_N W MODELTYPE=RLGC N=1
+ Lo=
+ 3.32029740e-07
+ Co=
+ 1.03489020e-10
+ Ro=
+ 3.96831067e+00
+ Go=
+ 0.00000000e+00
+ Rs=
+ 1.55902417e-03
+ Gd=
+ 2.04067990e-11

.Model Wmodel_Trace816::MIPI_DSI1_DATA3_N W MODELTYPE=RLGC N=1
+ Lo=
+ 3.32029740e-07
+ Co=
+ 1.03489020e-10
+ Ro=
+ 3.96831067e+00
+ Go=
+ 0.00000000e+00
+ Rs=
+ 1.55902417e-03
+ Gd=
+ 2.04067990e-11

.Model Wmodel_Trace818::MIPI_DSI1_DATA3_N W MODELTYPE=RLGC N=1
+ Lo=
+ 3.32029740e-07
+ Co=
+ 1.03489020e-10
+ Ro=
+ 3.96831067e+00
+ Go=
+ 0.00000000e+00
+ Rs=
+ 1.55902417e-03
+ Gd=
+ 2.04067990e-11

.Model Wmodel_Trace821::MIPI_DSI1_DATA3_N W MODELTYPE=RLGC N=1
+ Lo=
+ 3.32029740e-07
+ Co=
+ 1.03489020e-10
+ Ro=
+ 3.96831067e+00
+ Go=
+ 0.00000000e+00
+ Rs=
+ 1.55902417e-03
+ Gd=
+ 2.04067990e-11

.Model Wmodel_Trace823::MIPI_DSI1_DATA3_N W MODELTYPE=RLGC N=1
+ Lo=
+ 3.32029740e-07
+ Co=
+ 1.03489020e-10
+ Ro=
+ 3.96831067e+00
+ Go=
+ 0.00000000e+00
+ Rs=
+ 1.55902417e-03
+ Gd=
+ 2.04067990e-11

.Model Wmodel_Trace832::MIPI_DSI1_DATA3_N W MODELTYPE=RLGC N=1
+ Lo=
+ 3.32029740e-07
+ Co=
+ 1.03489020e-10
+ Ro=
+ 3.96831067e+00
+ Go=
+ 0.00000000e+00
+ Rs=
+ 1.55902417e-03
+ Gd=
+ 2.04067990e-11

.Model Wmodel_Trace834#BP0::MIPI_DSI1_DATA3_N W MODELTYPE=RLGC N=2
+ Lo=
+ 3.30812626e-07
+ 4.12606258e-08 3.30812626e-07
+ Co=
+ 1.03787267e-10
+ -4.36948100e-12 1.03787267e-10
+ Ro=
+ 3.96831067e+00
+ 0.00000000e+00 3.96831067e+00
+ Go=
+ 0.00000000e+00
+ -0.00000000e+00 0.00000000e+00
+ Rs=
+ 1.55902417e-03
+ -0.00000000e+00 1.55902417e-03
+ Gd=
+ 2.03832867e-11
+ -1.60091039e-13 2.03832867e-11

.Model Wmodel_Trace834#BP0_Auto_1835::MIPI_DSI1_DATA3_N W MODELTYPE=RLGC N=1
+ Lo=
+ 3.32029740e-07
+ Co=
+ 1.03489020e-10
+ Ro=
+ 3.96831067e+00
+ Go=
+ 0.00000000e+00
+ Rs=
+ 1.55902417e-03
+ Gd=
+ 2.04067990e-11

.Model Wmodel_Trace854::MIPI_DSI1_DATA3_N W MODELTYPE=RLGC N=1
+ Lo=
+ 3.32029740e-07
+ Co=
+ 1.03489020e-10
+ Ro=
+ 3.96831067e+00
+ Go=
+ 0.00000000e+00
+ Rs=
+ 1.55902417e-03
+ Gd=
+ 2.04067990e-11

.Model Wmodel_Trace856::MIPI_DSI1_DATA3_N W MODELTYPE=RLGC N=1
+ Lo=
+ 3.32029740e-07
+ Co=
+ 1.03489020e-10
+ Ro=
+ 3.96831067e+00
+ Go=
+ 0.00000000e+00
+ Rs=
+ 1.55902417e-03
+ Gd=
+ 2.04067990e-11

.Model Wmodel_Trace856_Auto_1839::MIPI_DSI1_DATA3_N W MODELTYPE=RLGC N=2
+ Lo=
+ 3.30789178e-07
+ 4.15945532e-08 3.30789178e-07
+ Co=
+ 1.03794751e-10
+ -4.42535158e-12 1.03794751e-10
+ Ro=
+ 3.96831067e+00
+ 0.00000000e+00 3.96831067e+00
+ Go=
+ 0.00000000e+00
+ -0.00000000e+00 0.00000000e+00
+ Rs=
+ 1.55902417e-03
+ -0.00000000e+00 1.55902417e-03
+ Gd=
+ 2.03830730e-11
+ -1.65605629e-13 2.03830730e-11

.Model Wmodel_Trace856_Auto_1840::MIPI_DSI1_DATA3_N W MODELTYPE=RLGC N=1
+ Lo=
+ 3.32029740e-07
+ Co=
+ 1.03489020e-10
+ Ro=
+ 3.96831067e+00
+ Go=
+ 0.00000000e+00
+ Rs=
+ 1.55902417e-03
+ Gd=
+ 2.04067990e-11

.Model Wmodel_Trace858::MIPI_DSI1_DATA3_N W MODELTYPE=RLGC N=1
+ Lo=
+ 3.32029740e-07
+ Co=
+ 1.03489020e-10
+ Ro=
+ 3.96831067e+00
+ Go=
+ 0.00000000e+00
+ Rs=
+ 1.55902417e-03
+ Gd=
+ 2.04067990e-11

.Model Wmodel_Trace860::MIPI_DSI1_DATA3_N W MODELTYPE=RLGC N=1
+ Lo=
+ 3.32029740e-07
+ Co=
+ 1.03489020e-10
+ Ro=
+ 3.96831067e+00
+ Go=
+ 0.00000000e+00
+ Rs=
+ 1.55902417e-03
+ Gd=
+ 2.04067990e-11

.Model Wmodel_Trace860_Auto_1841::MIPI_DSI1_DATA3_N W MODELTYPE=RLGC N=2
+ Lo=
+ 3.30679971e-07
+ 4.31020423e-08 3.30679971e-07
+ Co=
+ 1.03830221e-10
+ -4.68137220e-12 1.03830221e-10
+ Ro=
+ 3.96831067e+00
+ 0.00000000e+00 3.96831067e+00
+ Go=
+ 0.00000000e+00
+ -0.00000000e+00 0.00000000e+00
+ Rs=
+ 1.55902417e-03
+ -0.00000000e+00 1.55902417e-03
+ Gd=
+ 2.03821898e-11
+ -1.91390818e-13 2.03821898e-11

.Model Wmodel_Trace864::MIPI_DSI1_DATA3_N W MODELTYPE=RLGC N=1
+ Lo=
+ 3.32029740e-07
+ Co=
+ 1.03489020e-10
+ Ro=
+ 3.96831067e+00
+ Go=
+ 0.00000000e+00
+ Rs=
+ 1.55902417e-03
+ Gd=
+ 2.04067990e-11

.Model Wmodel_Trace866::MIPI_DSI1_DATA3_N W MODELTYPE=RLGC N=2
+ Lo=
+ 3.30748904e-07
+ 4.21593990e-08 3.30748904e-07
+ Co=
+ 1.03807716e-10
+ -4.52055469e-12 1.03807716e-10
+ Ro=
+ 3.96831067e+00
+ 0.00000000e+00 3.96831067e+00
+ Go=
+ 0.00000000e+00
+ -0.00000000e+00 0.00000000e+00
+ Rs=
+ 1.55902417e-03
+ -0.00000000e+00 1.55902417e-03
+ Gd=
+ 2.03827260e-11
+ -1.75097034e-13 2.03827260e-11

.Model Wmodel_Trace867::MIPI_DSI1_DATA3_N W MODELTYPE=RLGC N=2
+ Lo=
+ 3.30748548e-07
+ 4.21643405e-08 3.30748548e-07
+ Co=
+ 1.03807831e-10
+ -4.52139143e-12 1.03807831e-10
+ Ro=
+ 3.96831067e+00
+ 0.00000000e+00 3.96831067e+00
+ Go=
+ 0.00000000e+00
+ -0.00000000e+00 0.00000000e+00
+ Rs=
+ 1.55902417e-03
+ -0.00000000e+00 1.55902417e-03
+ Gd=
+ 2.03827231e-11
+ -1.75180973e-13 2.03827231e-11

.Model Wmodel_Trace868::MIPI_DSI1_DATA3_N W MODELTYPE=RLGC N=2
+ Lo=
+ 3.30747262e-07
+ 4.21821942e-08 3.30747262e-07
+ Co=
+ 1.03808247e-10
+ -4.52441508e-12 1.03808247e-10
+ Ro=
+ 3.96831067e+00
+ 0.00000000e+00 3.96831067e+00
+ Go=
+ 0.00000000e+00
+ -0.00000000e+00 0.00000000e+00
+ Rs=
+ 1.55902417e-03
+ -0.00000000e+00 1.55902417e-03
+ Gd=
+ 2.03827124e-11
+ -1.75484369e-13 2.03827124e-11

.Model Wmodel_Trace869::MIPI_DSI1_DATA3_N W MODELTYPE=RLGC N=1
+ Lo=
+ 3.32029740e-07
+ Co=
+ 1.03489020e-10
+ Ro=
+ 3.96831067e+00
+ Go=
+ 0.00000000e+00
+ Rs=
+ 1.55902417e-03
+ Gd=
+ 2.04067990e-11

.Model Wmodel_Trace870::MIPI_DSI1_DATA3_N W MODELTYPE=RLGC N=2
+ Lo=
+ 3.31483690e-07
+ 2.93239108e-08 3.31483690e-07
+ Co=
+ 1.03596409e-10
+ -2.58292219e-12 1.03596409e-10
+ Ro=
+ 3.96831067e+00
+ 0.00000000e+00 3.96831067e+00
+ Go=
+ 0.00000000e+00
+ -0.00000000e+00 0.00000000e+00
+ Rs=
+ 1.55902417e-03
+ -0.00000000e+00 1.55902417e-03
+ Gd=
+ 2.03932636e-11
+ -1.20430265e-14 2.03932636e-11

.Model Wmodel_Trace877::MIPI_DSI1_DATA3_P W MODELTYPE=RLGC N=1
+ Lo=
+ 3.32029740e-07
+ Co=
+ 1.03489020e-10
+ Ro=
+ 3.96831067e+00
+ Go=
+ 0.00000000e+00
+ Rs=
+ 1.55902417e-03
+ Gd=
+ 2.04067990e-11

.Model Wmodel_Trace879::MIPI_DSI1_DATA3_P W MODELTYPE=RLGC N=1
+ Lo=
+ 3.32029740e-07
+ Co=
+ 1.03489020e-10
+ Ro=
+ 3.96831067e+00
+ Go=
+ 0.00000000e+00
+ Rs=
+ 1.55902417e-03
+ Gd=
+ 2.04067990e-11

.Model Wmodel_Trace883::MIPI_DSI1_DATA3_P W MODELTYPE=RLGC N=1
+ Lo=
+ 3.32029740e-07
+ Co=
+ 1.03489020e-10
+ Ro=
+ 3.96831067e+00
+ Go=
+ 0.00000000e+00
+ Rs=
+ 1.55902417e-03
+ Gd=
+ 2.04067990e-11

.Model Wmodel_Trace885::MIPI_DSI1_DATA3_P W MODELTYPE=RLGC N=2
+ Lo=
+ 3.30679690e-07
+ 4.31058267e-08 3.30679690e-07
+ Co=
+ 1.03830313e-10
+ -4.68202267e-12 1.03830313e-10
+ Ro=
+ 3.96831067e+00
+ 0.00000000e+00 3.96831067e+00
+ Go=
+ 0.00000000e+00
+ -0.00000000e+00 0.00000000e+00
+ Rs=
+ 1.55902417e-03
+ -0.00000000e+00 1.55902417e-03
+ Gd=
+ 2.03821877e-11
+ -1.91457368e-13 2.03821877e-11

.Model Wmodel_Trace885_Auto_1838::MIPI_DSI1_DATA3_P W MODELTYPE=RLGC N=4
+ Lo=
+ 3.30728126e-07
+ 4.09571895e-08 3.29428202e-07
+ 1.17817516e-08 4.22146727e-08 3.29371238e-07
+ 5.19915574e-09 1.19288700e-08 4.17935000e-08 3.30666620e-07
+ Co=
+ 1.03793797e-10
+ -4.33154624e-12 1.04120801e-10
+ -5.24170297e-13 -4.55310332e-12 1.04139602e-10
+ -2.31493269e-13 -5.29232890e-13 -4.47243276e-12 1.03812987e-10
+ Ro=
+ 3.96831067e+00
+ 0.00000000e+00 3.96831067e+00
+ 0.00000000e+00 0.00000000e+00 3.96831067e+00
+ 0.00000000e+00 0.00000000e+00 0.00000000e+00 3.96831067e+00
+ Go=
+ 0.00000000e+00
+ -0.00000000e+00 0.00000000e+00
+ -0.00000000e+00 -0.00000000e+00 0.00000000e+00
+ -0.00000000e+00 -0.00000000e+00 -0.00000000e+00 0.00000000e+00
+ Rs=
+ 1.55902417e-03
+ -0.00000000e+00 1.55902417e-03
+ -0.00000000e+00 -0.00000000e+00 1.55902417e-03
+ -0.00000000e+00 -0.00000000e+00 -0.00000000e+00 1.55902417e-03
+ Gd=
+ 2.03824480e-11
+ -1.65013405e-13 2.03592837e-11
+ -0.00000000e+00 -1.94123966e-13 2.03588027e-11
+ -0.00000000e+00 -0.00000000e+00 -1.79058895e-13 2.03819133e-11

.Model Wmodel_Trace894::MIPI_DSI1_DATA3_P W MODELTYPE=RLGC N=1
+ Lo=
+ 3.32029740e-07
+ Co=
+ 1.03489020e-10
+ Ro=
+ 3.96831067e+00
+ Go=
+ 0.00000000e+00
+ Rs=
+ 1.55902417e-03
+ Gd=
+ 2.04067990e-11

.Model Wmodel_Trace905::MIPI_DSI1_DATA3_P W MODELTYPE=RLGC N=1
+ Lo=
+ 3.32029740e-07
+ Co=
+ 1.03489020e-10
+ Ro=
+ 3.96831067e+00
+ Go=
+ 0.00000000e+00
+ Rs=
+ 1.55902417e-03
+ Gd=
+ 2.04067990e-11

.Model Wmodel_Trace907_Auto_1836::MIPI_DSI1_DATA3_P W MODELTYPE=RLGC N=1
+ Lo=
+ 3.32029740e-07
+ Co=
+ 1.03489020e-10
+ Ro=
+ 3.96831067e+00
+ Go=
+ 0.00000000e+00
+ Rs=
+ 1.55902417e-03
+ Gd=
+ 2.04067990e-11

.Model Wmodel_Trace916::MIPI_DSI1_DATA3_P W MODELTYPE=RLGC N=1
+ Lo=
+ 3.32029740e-07
+ Co=
+ 1.03489020e-10
+ Ro=
+ 3.96831067e+00
+ Go=
+ 0.00000000e+00
+ Rs=
+ 1.55902417e-03
+ Gd=
+ 2.04067990e-11

.Model Wmodel_Trace922::MIPI_DSI1_DATA3_P W MODELTYPE=RLGC N=1
+ Lo=
+ 3.32029740e-07
+ Co=
+ 1.03489020e-10
+ Ro=
+ 3.96831067e+00
+ Go=
+ 0.00000000e+00
+ Rs=
+ 1.55902417e-03
+ Gd=
+ 2.04067990e-11

.Model Wmodel_Trace926::MIPI_DSI1_DATA3_P W MODELTYPE=RLGC N=1
+ Lo=
+ 3.32029740e-07
+ Co=
+ 1.03489020e-10
+ Ro=
+ 3.96831067e+00
+ Go=
+ 0.00000000e+00
+ Rs=
+ 1.55902417e-03
+ Gd=
+ 2.04067990e-11

.Model Wmodel_Trace928::MIPI_DSI1_DATA3_P W MODELTYPE=RLGC N=1
+ Lo=
+ 3.32029740e-07
+ Co=
+ 1.03489020e-10
+ Ro=
+ 3.96831067e+00
+ Go=
+ 0.00000000e+00
+ Rs=
+ 1.55902417e-03
+ Gd=
+ 2.04067990e-11

.Model Wmodel_Trace928_Auto_1843::MIPI_DSI1_DATA3_P W MODELTYPE=RLGC N=1
+ Lo=
+ 3.32029740e-07
+ Co=
+ 1.03489020e-10
+ Ro=
+ 3.96831067e+00
+ Go=
+ 0.00000000e+00
+ Rs=
+ 1.55902417e-03
+ Gd=
+ 2.04067990e-11

.Model Wmodel_Trace932::MIPI_DSI1_DATA3_P W MODELTYPE=RLGC N=1
+ Lo=
+ 3.32029740e-07
+ Co=
+ 1.03489020e-10
+ Ro=
+ 3.96831067e+00
+ Go=
+ 0.00000000e+00
+ Rs=
+ 1.55902417e-03
+ Gd=
+ 2.04067990e-11

.Model Wmodel_Trace934::MIPI_DSI1_DATA3_P W MODELTYPE=RLGC N=1
+ Lo=
+ 3.32029740e-07
+ Co=
+ 1.03489020e-10
+ Ro=
+ 3.96831067e+00
+ Go=
+ 0.00000000e+00
+ Rs=
+ 1.55902417e-03
+ Gd=
+ 2.04067990e-11

.Model Wmodel_Trace934_Auto_1845::MIPI_DSI1_DATA3_P W MODELTYPE=RLGC N=1
+ Lo=
+ 3.32029740e-07
+ Co=
+ 1.03489020e-10
+ Ro=
+ 3.96831067e+00
+ Go=
+ 0.00000000e+00
+ Rs=
+ 1.55902417e-03
+ Gd=
+ 2.04067990e-11

.Model Wmodel_Trace935::MIPI_DSI1_DATA3_P W MODELTYPE=RLGC N=1
+ Lo=
+ 3.32029740e-07
+ Co=
+ 1.03489020e-10
+ Ro=
+ 3.96831067e+00
+ Go=
+ 0.00000000e+00
+ Rs=
+ 1.55902417e-03
+ Gd=
+ 2.04067990e-11

.Model Wmodel_Trace935_Auto_1847::MIPI_DSI1_DATA3_P W MODELTYPE=RLGC N=1
+ Lo=
+ 3.32029740e-07
+ Co=
+ 1.03489020e-10
+ Ro=
+ 3.96831067e+00
+ Go=
+ 0.00000000e+00
+ Rs=
+ 1.55902417e-03
+ Gd=
+ 2.04067990e-11

.Model Wmodel_Trace936::MIPI_DSI1_DATA3_P W MODELTYPE=RLGC N=1
+ Lo=
+ 3.32029740e-07
+ Co=
+ 1.03489020e-10
+ Ro=
+ 3.96831067e+00
+ Go=
+ 0.00000000e+00
+ Rs=
+ 1.55902417e-03
+ Gd=
+ 2.04067990e-11

.Model Wmodel_Trace937::MIPI_DSI1_DATA3_P W MODELTYPE=RLGC N=1
+ Lo=
+ 3.32029740e-07
+ Co=
+ 1.03489020e-10
+ Ro=
+ 3.96831067e+00
+ Go=
+ 0.00000000e+00
+ Rs=
+ 1.55902417e-03
+ Gd=
+ 2.04067990e-11

.Model Wmodel_Trace943_Auto_760::MIPI_DSI1_DATA3_P W MODELTYPE=RLGC N=3
+ Lo=
+ 3.30601206e-07
+ 4.15190111e-08 3.27383562e-07
+ 1.23231008e-08 4.55929266e-08 2.63712020e-07
+ Co=
+ 1.03815659e-10
+ -4.46237444e-12 1.04503947e-10
+ -7.06543412e-13 -7.03040873e-12 1.38290155e-10
+ Ro=
+ 3.96831067e+00
+ 0.00000000e+00 3.96831067e+00
+ 0.00000000e+00 0.00000000e+00 2.42066951e+00
+ Go=
+ 0.00000000e+00
+ -0.00000000e+00 0.00000000e+00
+ -0.00000000e+00 -0.00000000e+00 0.00000000e+00
+ Rs=
+ 1.55902417e-03
+ -0.00000000e+00 1.55902417e-03
+ -0.00000000e+00 -0.00000000e+00 1.18814509e-03
+ Gd=
+ 2.03818158e-11
+ -1.81529135e-13 2.03583430e-11
+ -0.00000000e+00 -4.28618942e-13 2.79838561e-11

.Model Wmodel_Trace944::MIPI_DSI1_DATA3_P W MODELTYPE=RLGC N=1
+ Lo=
+ 3.32029740e-07
+ Co=
+ 1.03489020e-10
+ Ro=
+ 3.96831067e+00
+ Go=
+ 0.00000000e+00
+ Rs=
+ 1.55902417e-03
+ Gd=
+ 2.04067990e-11

.Model Wmodel_Trace945::MIPI_DSI1_DATA3_P W MODELTYPE=RLGC N=3
+ Lo=
+ 3.30715470e-07
+ 4.00199033e-08 3.27487472e-07
+ 1.20460239e-08 4.56124462e-08 2.63715899e-07
+ Co=
+ 1.03781404e-10
+ -4.20943099e-12 1.04470512e-10
+ -6.95381728e-13 -7.03364772e-12 1.38289860e-10
+ Ro=
+ 3.96831067e+00
+ 0.00000000e+00 3.96831067e+00
+ 0.00000000e+00 0.00000000e+00 2.42066951e+00
+ Go=
+ 0.00000000e+00
+ -0.00000000e+00 0.00000000e+00
+ -0.00000000e+00 -0.00000000e+00 0.00000000e+00
+ Rs=
+ 1.55902417e-03
+ -0.00000000e+00 1.55902417e-03
+ -0.00000000e+00 -0.00000000e+00 1.18814509e-03
+ Gd=
+ 2.03828093e-11
+ -1.56395355e-13 2.03592246e-11
+ -0.00000000e+00 -4.28376781e-13 2.79838819e-11

.Model Wmodel_Trace945_Auto_768::MIPI_DSI1_DATA3_P W MODELTYPE=RLGC N=1
+ Lo=
+ 3.32029740e-07
+ Co=
+ 1.03489020e-10
+ Ro=
+ 3.96831067e+00
+ Go=
+ 0.00000000e+00
+ Rs=
+ 1.55902417e-03
+ Gd=
+ 2.04067990e-11

.Model Wmodel_Trace946::MIPI_DSI1_DATA3_P W MODELTYPE=RLGC N=2
+ Lo=
+ 3.30748548e-07
+ 4.21643423e-08 3.30748548e-07
+ Co=
+ 1.03807831e-10
+ -4.52139172e-12 1.03807831e-10
+ Ro=
+ 3.96831067e+00
+ 0.00000000e+00 3.96831067e+00
+ Go=
+ 0.00000000e+00
+ -0.00000000e+00 0.00000000e+00
+ Rs=
+ 1.55902417e-03
+ -0.00000000e+00 1.55902417e-03
+ Gd=
+ 2.03827231e-11
+ -1.75181003e-13 2.03827231e-11

.Model Wmodel_Trace946_Auto_999::MIPI_DSI1_DATA3_P W MODELTYPE=RLGC N=2
+ Lo=
+ 3.30715119e-07
+ 4.26250861e-08 3.30715119e-07
+ Co=
+ 1.03818696e-10
+ -4.59970040e-12 1.03818696e-10
+ Ro=
+ 3.96831067e+00
+ 0.00000000e+00 3.96831067e+00
+ Go=
+ 0.00000000e+00
+ -0.00000000e+00 0.00000000e+00
+ Rs=
+ 1.55902417e-03
+ -0.00000000e+00 1.55902417e-03
+ Gd=
+ 2.03824542e-11
+ -1.83075845e-13 2.03824542e-11

.Model Wmodel_Trace948::MIPI_DSI1_DATA3_P W MODELTYPE=RLGC N=1
+ Lo=
+ 3.32029740e-07
+ Co=
+ 1.03489020e-10
+ Ro=
+ 3.96831067e+00
+ Go=
+ 0.00000000e+00
+ Rs=
+ 1.55902417e-03
+ Gd=
+ 2.04067990e-11

.Model Wmodel_Trace952::MIPI_DSI1_DATA3_P W MODELTYPE=RLGC N=1
+ Lo=
+ 3.32029740e-07
+ Co=
+ 1.03489020e-10
+ Ro=
+ 3.96831067e+00
+ Go=
+ 0.00000000e+00
+ Rs=
+ 1.55902417e-03
+ Gd=
+ 2.04067990e-11

.Model Wmodel_Trace954::MIPI_DSI1_DATA3_P W MODELTYPE=RLGC N=2
+ Lo=
+ 3.30739749e-07
+ 4.22863111e-08 3.30739749e-07
+ Co=
+ 1.03810682e-10
+ -4.54206543e-12 1.03810682e-10
+ Ro=
+ 3.96831067e+00
+ 0.00000000e+00 3.96831067e+00
+ Go=
+ 0.00000000e+00
+ -0.00000000e+00 0.00000000e+00
+ Rs=
+ 1.55902417e-03
+ -0.00000000e+00 1.55902417e-03
+ Gd=
+ 2.03826506e-11
+ -1.77257747e-13 2.03826506e-11

.Model Wmodel_Trace958::MIPI_DSI1_DATA3_P W MODELTYPE=RLGC N=1
+ Lo=
+ 3.32029740e-07
+ Co=
+ 1.03489020e-10
+ Ro=
+ 3.96831067e+00
+ Go=
+ 0.00000000e+00
+ Rs=
+ 1.55902417e-03
+ Gd=
+ 2.04067990e-11

.Model Wmodel_Trace960::MIPI_DSI1_DATA3_P W MODELTYPE=RLGC N=2
+ Lo=
+ 3.30748548e-07
+ 4.21643423e-08 3.30748548e-07
+ Co=
+ 1.03807831e-10
+ -4.52139172e-12 1.03807831e-10
+ Ro=
+ 3.96831067e+00
+ 0.00000000e+00 3.96831067e+00
+ Go=
+ 0.00000000e+00
+ -0.00000000e+00 0.00000000e+00
+ Rs=
+ 1.55902417e-03
+ -0.00000000e+00 1.55902417e-03
+ Gd=
+ 2.03827231e-11
+ -1.75181003e-13 2.03827231e-11

.Model Wmodel_Trace962::MIPI_DSI1_DATA3_P W MODELTYPE=RLGC N=1
+ Lo=
+ 3.32029740e-07
+ Co=
+ 1.03489020e-10
+ Ro=
+ 3.96831067e+00
+ Go=
+ 0.00000000e+00
+ Rs=
+ 1.55902417e-03
+ Gd=
+ 2.04067990e-11

.Model Wmodel_Trace964::MIPI_DSI1_DATA3_P W MODELTYPE=RLGC N=2
+ Lo=
+ 3.30740391e-07
+ 4.22774243e-08 3.30740391e-07
+ Co=
+ 1.03810473e-10
+ -4.54055774e-12 1.03810473e-10
+ Ro=
+ 3.96831067e+00
+ 0.00000000e+00 3.96831067e+00
+ Go=
+ 0.00000000e+00
+ -0.00000000e+00 0.00000000e+00
+ Rs=
+ 1.55902417e-03
+ -0.00000000e+00 1.55902417e-03
+ Gd=
+ 2.03826559e-11
+ -1.77106111e-13 2.03826559e-11

.Model Wmodel_Trace965#BP0::MIPI_DSI1_DATA3_P W MODELTYPE=RLGC N=2
+ Lo=
+ 3.31141023e-07
+ 3.61120642e-08 3.31141023e-07
+ Co=
+ 1.03687796e-10
+ -3.54765767e-12 1.03687796e-10
+ Ro=
+ 3.96831067e+00
+ 0.00000000e+00 3.96831067e+00
+ Go=
+ 0.00000000e+00
+ -0.00000000e+00 0.00000000e+00
+ Rs=
+ 1.55902417e-03
+ -0.00000000e+00 1.55902417e-03
+ Gd=
+ 2.03872091e-11
+ -8.43452651e-14 2.03872091e-11

.Model Wmodel_Trace966::MIPI_DSI1_DATA3_P W MODELTYPE=RLGC N=1
+ Lo=
+ 3.32029740e-07
+ Co=
+ 1.03489020e-10
+ Ro=
+ 3.96831067e+00
+ Go=
+ 0.00000000e+00
+ Rs=
+ 1.55902417e-03
+ Gd=
+ 2.04067990e-11

.Model Wmodel_Trace971::MIPI_DSI1_DATA2_N W MODELTYPE=RLGC N=1
+ Lo=
+ 3.58484574e-07
+ Co=
+ 9.37055974e-11
+ Ro=
+ 4.84133902e+00
+ Go=
+ 0.00000000e+00
+ Rs=
+ 1.72420198e-03
+ Gd=
+ 1.82370500e-11

.Model Wmodel_Trace973::MIPI_DSI1_DATA2_N W MODELTYPE=RLGC N=1
+ Lo=
+ 3.58484574e-07
+ Co=
+ 9.37055974e-11
+ Ro=
+ 4.84133902e+00
+ Go=
+ 0.00000000e+00
+ Rs=
+ 1.72420198e-03
+ Gd=
+ 1.82370500e-11

.Model Wmodel_Trace975::MIPI_DSI1_DATA2_N W MODELTYPE=RLGC N=1
+ Lo=
+ 3.32029740e-07
+ Co=
+ 1.03489020e-10
+ Ro=
+ 3.96831067e+00
+ Go=
+ 0.00000000e+00
+ Rs=
+ 1.55902417e-03
+ Gd=
+ 2.04067990e-11

.Model Wmodel_Trace978::MIPI_DSI1_DATA2_N W MODELTYPE=RLGC N=1
+ Lo=
+ 3.32029740e-07
+ Co=
+ 1.03489020e-10
+ Ro=
+ 3.96831067e+00
+ Go=
+ 0.00000000e+00
+ Rs=
+ 1.55902417e-03
+ Gd=
+ 2.04067990e-11

.Model Wmodel_Trace979::MIPI_DSI1_DATA2_N W MODELTYPE=RLGC N=3
+ Lo=
+ 3.30536467e-07
+ 4.36968155e-08 3.29348102e-07
+ 1.22439114e-08 4.18548768e-08 3.30672143e-07
+ Co=
+ 1.03857943e-10
+ -4.79720114e-12 1.04165599e-10
+ -5.51023583e-13 -4.48076288e-12 1.03813293e-10
+ Ro=
+ 3.96831067e+00
+ 0.00000000e+00 3.96831067e+00
+ 0.00000000e+00 0.00000000e+00 3.96831067e+00
+ Go=
+ 0.00000000e+00
+ -0.00000000e+00 0.00000000e+00
+ -0.00000000e+00 -0.00000000e+00 0.00000000e+00
+ Rs=
+ 1.55902417e-03
+ -0.00000000e+00 1.55902417e-03
+ -0.00000000e+00 -0.00000000e+00 1.55902417e-03
+ Gd=
+ 2.03810138e-11
+ -2.11685665e-13 2.03588259e-11
+ -0.00000000e+00 -1.79752651e-13 2.03820020e-11

.Model Wmodel_Trace979_Auto_991::MIPI_DSI1_DATA2_N W MODELTYPE=RLGC N=3
+ Lo=
+ 3.30536467e-07
+ 4.36968155e-08 3.29348102e-07
+ 1.22439114e-08 4.18548768e-08 3.30672143e-07
+ Co=
+ 1.03857943e-10
+ -4.79720114e-12 1.04165599e-10
+ -5.51023583e-13 -4.48076288e-12 1.03813293e-10
+ Ro=
+ 3.96831067e+00
+ 0.00000000e+00 3.96831067e+00
+ 0.00000000e+00 0.00000000e+00 3.96831067e+00
+ Go=
+ 0.00000000e+00
+ -0.00000000e+00 0.00000000e+00
+ -0.00000000e+00 -0.00000000e+00 0.00000000e+00
+ Rs=
+ 1.55902417e-03
+ -0.00000000e+00 1.55902417e-03
+ -0.00000000e+00 -0.00000000e+00 1.55902417e-03
+ Gd=
+ 2.03810138e-11
+ -2.11685665e-13 2.03588259e-11
+ -0.00000000e+00 -1.79752651e-13 2.03820020e-11

.Model Wmodel_Trace980::MIPI_DSI1_DATA2_N W MODELTYPE=RLGC N=1
+ Lo=
+ 3.32029740e-07
+ Co=
+ 1.03489020e-10
+ Ro=
+ 3.96831067e+00
+ Go=
+ 0.00000000e+00
+ Rs=
+ 1.55902417e-03
+ Gd=
+ 2.04067990e-11

.Model Wmodel_Trace983::MIPI_DSI1_DATA2_N W MODELTYPE=RLGC N=1
+ Lo=
+ 3.32029740e-07
+ Co=
+ 1.03489020e-10
+ Ro=
+ 3.96831067e+00
+ Go=
+ 0.00000000e+00
+ Rs=
+ 1.55902417e-03
+ Gd=
+ 2.04067990e-11

.Model Wmodel_Trace986::MIPI_DSI1_DATA2_N W MODELTYPE=RLGC N=1
+ Lo=
+ 3.32029740e-07
+ Co=
+ 1.03489020e-10
+ Ro=
+ 3.96831067e+00
+ Go=
+ 0.00000000e+00
+ Rs=
+ 1.55902417e-03
+ Gd=
+ 2.04067990e-11

.Model Wmodel_Trace988::MIPI_DSI1_DATA2_N W MODELTYPE=RLGC N=1
+ Lo=
+ 3.32029740e-07
+ Co=
+ 1.03489020e-10
+ Ro=
+ 3.96831067e+00
+ Go=
+ 0.00000000e+00
+ Rs=
+ 1.55902417e-03
+ Gd=
+ 2.04067990e-11

.Model Wmodel_Trace988_Auto_1876::MIPI_DSI1_DATA2_N W MODELTYPE=RLGC N=1
+ Lo=
+ 3.32029740e-07
+ Co=
+ 1.03489020e-10
+ Ro=
+ 3.96831067e+00
+ Go=
+ 0.00000000e+00
+ Rs=
+ 1.55902417e-03
+ Gd=
+ 2.04067990e-11

.Model Wmodel_Trace989::MIPI_DSI1_DATA2_N W MODELTYPE=RLGC N=1
+ Lo=
+ 3.32029740e-07
+ Co=
+ 1.03489020e-10
+ Ro=
+ 3.96831067e+00
+ Go=
+ 0.00000000e+00
+ Rs=
+ 1.55902417e-03
+ Gd=
+ 2.04067990e-11

.Model Wmodel_Trace989_Auto_1882::MIPI_DSI1_DATA2_N W MODELTYPE=RLGC N=1
+ Lo=
+ 3.32029740e-07
+ Co=
+ 1.03489020e-10
+ Ro=
+ 3.96831067e+00
+ Go=
+ 0.00000000e+00
+ Rs=
+ 1.55902417e-03
+ Gd=
+ 2.04067990e-11

.Model Wmodel_Trace999::MIPI_DSI1_DATA2_N W MODELTYPE=RLGC N=1
+ Lo=
+ 3.32029740e-07
+ Co=
+ 1.03489020e-10
+ Ro=
+ 3.96831067e+00
+ Go=
+ 0.00000000e+00
+ Rs=
+ 1.55902417e-03
+ Gd=
+ 2.04067990e-11
