.SUBCKT		#Taaaahm19560_041226_203052_24476_S
+			CH1_1
+			CH1_10
+			CH1_11
+			CH1_12
+			CH1_13
+			CH1_14
+			CH1_15
+			CH1_16
+			CH1_17
+			CH1_18
+			CH1_19
+			CH1_2
+			CH1_20
+			CH1_21
+			CH1_25
+			CH1_26
+			CH1_27
+			CH1_28
+			CH1_3
+			CH1_33
+			CH1_34
+			CH1_35
+			CH1_37
+			CH1_38
+			CH1_4
+			CH1_5
+			CH1_6
+			CH1_7
+			CH1_8
+			CH1_9
*The following is the Cadence MCP(model connection protocol) Section
***********************************
*[MCP Begin]
*[MCP Ver] 1.1
*[MCP Source] Cadence Design Systems, Inc. Layout Workbench 21.1.4.11171.321455   004 4/12/2026
*
***********************************
*
*[REM]The following is the info for component connection CH1
*[REM]**********************************
*[Connection] CH1 WP7B-P040VA1-R8000_WP7B-P040VA1-R8000_WP7B-P040VA1-R8000_WP7B-P040VA1-R8000 44
*[Power Nets]
*[Ground Nets]
*21	CH1_21	GND	0.2688189	0.2436777
*25	CH1_25	GND	0.2688189	0.2420775
*26	CH1_26	GND	0.2688189	0.2416777
*27	CH1_27	GND	0.2688189	0.2412776
*28	CH1_28	GND	0.2688189	0.2408776
*33	CH1_33	GND	0.2688189	0.2388776
*34	CH1_34	GND	0.2688189	0.2384776
*35	CH1_35	GND	0.2688189	0.2380775
*37	CH1_37	GND	0.2688189	0.2372777
*38	CH1_38	GND	0.2688189	0.2368776
*[Signal Nets]
*1	CH1_1	MIPI_DSI0_DATA3_N	0.2669687	0.2360775
*10	CH1_10	MIPI_DSI0_DATA2_P	0.2669687	0.2396777
*11	CH1_11	MIPI_DSI1_DATA2_P	0.2669687	0.2400775
*12	CH1_12	MIPI_DSI1_DATA2_N	0.2669687	0.2404775
*13	CH1_13	MIPI_DSI1_DATA1_P	0.2669687	0.2408776
*14	CH1_14	MIPI_DSI1_DATA1_N	0.2669687	0.2412776
*15	CH1_15	MIPI_DSI1_CLK_P	0.2669687	0.2416777
*16	CH1_16	MIPI_DSI1_CLK_N	0.2669687	0.2420775
*17	CH1_17	MIPI_DSI1_DATA0_P	0.2669687	0.2424775
*18	CH1_18	MIPI_DSI1_DATA0_N	0.2669687	0.2428776
*19	CH1_19	MIPI_DSI1_DATA3_P	0.2669687	0.2432776
*2	CH1_2	MIPI_DSI0_DATA3_P	0.2669687	0.2364776
*20	CH1_20	MIPI_DSI1_DATA3_N	0.2669687	0.2436777
*3	CH1_3	MIPI_DSI0_DATA0_N	0.2669687	0.2368776
*4	CH1_4	MIPI_DSI0_DATA0_P	0.2669687	0.2372777
*5	CH1_5	MIPI_DSI0_CLK_N	0.2669687	0.2376777
*6	CH1_6	MIPI_DSI0_CLK_P	0.2669687	0.2380775
*7	CH1_7	MIPI_DSI0_DATA1_N	0.2669687	0.2384776
*8	CH1_8	MIPI_DSI0_DATA1_P	0.2669687	0.2388776
*9	CH1_9	MIPI_DSI0_DATA2_N	0.2669687	0.2392777
*
*[MCP End]
*
*This concludes the MCP section
*Define the S element, the Model file is output from BNP

.MODEL   Spara   S
+		TSTONEFILE = "#Taaaahm19560_041226_203052_24476_S.ts"

S
+			CH1_19	CH1_21
+			CH1_20	CH1_21
+			CH1_11	CH1_28
+			CH1_12	CH1_28
+			CH1_15	CH1_26
+			CH1_16	CH1_25
+			CH1_13	CH1_28
+			CH1_14	CH1_27
+			CH1_17	CH1_25
+			CH1_18	CH1_21
+			CH1_2	CH1_38
+			CH1_1	CH1_38
+			CH1_10	CH1_33
+			CH1_9	CH1_33
+			CH1_6	CH1_35
+			CH1_5	CH1_35
+			CH1_8	CH1_33
+			CH1_7	CH1_34
+			CH1_4	CH1_37
+			CH1_3	CH1_38
+			MNAME = Spara

*
.ENDS
*
*
