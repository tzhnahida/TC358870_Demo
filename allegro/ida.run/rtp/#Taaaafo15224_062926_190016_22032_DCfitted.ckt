.SUBCKT		#Taaaafo15224_062926_190016_22032_DCfitted
+			CH2_1
+			CH2_10
+			CH2_11
+			CH2_12
+			CH2_13
+			CH2_14
+			CH2_15
+			CH2_16
+			CH2_17
+			CH2_18
+			CH2_19
+			CH2_2
+			CH2_20
+			CH2_21
+			CH2_25
+			CH2_26
+			CH2_27
+			CH2_28
+			CH2_3
+			CH2_33
+			CH2_34
+			CH2_35
+			CH2_4
+			CH2_5
+			CH2_6
+			CH2_7
+			CH2_8
+			CH2_9
+			U9_A3
+			U9_B3
+			U9_C1
+			U9_C2
+			U9_D1
+			U9_D2
+			U9_D4
+			U9_E1
+			U9_E2
+			U9_E4
+			U9_F1
+			U9_F2
+			U9_F4
+			U9_H1
*The following is the Cadence MCP(model connection protocol) Section
***********************************
*[MCP Begin]
*[MCP Ver] 1.1
*[MCP Source] Cadence Design Systems, Inc. Layout Workbench 21.1.4.11171.321455   004 6/29/2026
*
***********************************
*
*[REM]The following is the info for component connection CH2
*[REM]**********************************
*[Connection] CH2 WP7B-S040VA1-R8000_WP7B-S040VA1-R8000_WP7B-S040VA1-R8000_WP7B-S040VA1-R8000 44
*[Power Nets]
*[Ground Nets]
*21	CH2_21	GND	0.0489280	0.1148232
*25	CH2_25	GND	0.0489280	0.1132230
*26	CH2_26	GND	0.0489280	0.1128243
*27	CH2_27	GND	0.0489280	0.1124229
*28	CH2_28	GND	0.0489280	0.1120242
*33	CH2_33	GND	0.0489280	0.1100252
*34	CH2_34	GND	0.0489280	0.1096239
*35	CH2_35	GND	0.0489280	0.1092251
*[Signal Nets]
*1	CH2_1	MIPI_DSI0_DATA3_N	0.0465277	0.1072236
*10	CH2_10	MIPI_DSI0_DATA2_P	0.0465277	0.1108227
*11	CH2_11	MIPI_DSI1_DATA2_P	0.0465277	0.1112241
*12	CH2_12	MIPI_DSI1_DATA2_N	0.0465277	0.1116228
*13	CH2_13	MIPI_DSI1_DATA1_P	0.0465277	0.1120242
*14	CH2_14	MIPI_DSI1_DATA1_N	0.0465277	0.1124229
*15	CH2_15	MIPI_DSI1_CLK_P	0.0465277	0.1128243
*16	CH2_16	MIPI_DSI1_CLK_N	0.0465277	0.1132230
*17	CH2_17	MIPI_DSI1_DATA0_P	0.0465277	0.1136244
*18	CH2_18	MIPI_DSI1_DATA0_N	0.0465277	0.1140231
*19	CH2_19	MIPI_DSI1_DATA3_P	0.0465277	0.1144245
*2	CH2_2	MIPI_DSI0_DATA3_P	0.0465277	0.1076249
*20	CH2_20	MIPI_DSI1_DATA3_N	0.0465277	0.1148232
*3	CH2_3	MIPI_DSI0_DATA0_N	0.0465277	0.1080237
*4	CH2_4	MIPI_DSI0_DATA0_P	0.0465277	0.1084250
*5	CH2_5	MIPI_DSI0_CLK_N	0.0465277	0.1088238
*6	CH2_6	MIPI_DSI0_CLK_P	0.0465277	0.1092251
*7	CH2_7	MIPI_DSI0_DATA1_N	0.0465277	0.1096239
*8	CH2_8	MIPI_DSI0_DATA1_P	0.0465277	0.1100252
*9	CH2_9	MIPI_DSI0_DATA2_N	0.0465277	0.1104240
*
*[REM]The following is the info for component connection U9
*[REM]**********************************
*[Connection] U9 TC358870XBG_1_VFBGA80_(S1+S2+S3+S4)_TC358870XBG(NOK)_TC358870XBG(NOK) 80
*[Power Nets]
*[Ground Nets]
*D4	U9_D4	GND	0.0265727	0.1082647
*E4	U9_E4	GND	0.0265727	0.1076145
*F4	U9_F4	GND	0.0265727	0.1069645
*H1	U9_H1	GND	0.0246228	0.1056645
*[Signal Nets]
*A3	U9_A3	SCL	0.0259227	0.1102147
*B3	U9_B3	SDA	0.0259227	0.1095647
*C1	U9_C1	HDMI_CLK_P	0.0246228	0.1089147
*C2	U9_C2	HDMI_CLK_N	0.0252727	0.1089147
*D1	U9_D1	HDMI_DATA0_P	0.0246228	0.1082647
*D2	U9_D2	HDMI_DATA0_N	0.0252727	0.1082647
*E1	U9_E1	HDMI_DATA1_P	0.0246228	0.1076145
*E2	U9_E2	HDMI_DATA1_N	0.0252727	0.1076145
*F1	U9_F1	HDMI_DATA2_P	0.0246228	0.1069645
*F2	U9_F2	HDMI_DATA2_N	0.0252727	0.1069645
*
*[MCP End]
*
*This concludes the MCP section
*Define the S element, the Model file is output from BNP

.MODEL   Spara   S
+		TSTONEFILE = "#Taaaafo15224_062926_190016_22032_DCfitted.ts"

S
+			U9_A3	U9_D4
+			U9_B3	U9_D4
+			U9_F1	U9_H1
+			U9_F2	U9_F4
+			U9_C1	U9_D4
+			U9_C2	U9_D4
+			U9_E1	U9_H1
+			U9_E2	U9_E4
+			U9_D1	U9_D4
+			U9_D2	U9_D4
+			CH2_19	CH2_21
+			CH2_20	CH2_21
+			CH2_11	CH2_28
+			CH2_12	CH2_28
+			CH2_15	CH2_26
+			CH2_16	CH2_25
+			CH2_13	CH2_28
+			CH2_14	CH2_27
+			CH2_17	CH2_25
+			CH2_18	CH2_21
+			CH2_2	CH2_35
+			CH2_1	CH2_35
+			CH2_10	CH2_33
+			CH2_9	CH2_33
+			CH2_6	CH2_35
+			CH2_5	CH2_35
+			CH2_8	CH2_33
+			CH2_7	CH2_34
+			CH2_4	CH2_35
+			CH2_3	CH2_35
+			MNAME = Spara

*
.ENDS
*
*
