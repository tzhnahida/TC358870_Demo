*Wmodel Definition*
*TraceModel Definition*

.Model Wmodel_Trace2227::MIPI_DSI0_DATA0_N W MODELTYPE=RLGC N=1
+ Lo=
+ 3.58484574e-07
+ Co=
+ 9.37055974e-11
+ Ro=
+ 4.84133902e+00
+ Go=
+ 0.00000000e+00
+ Rs=
+ 1.72420198e-03
+ Gd=
+ 1.82370500e-11

.Model Wmodel_Trace2228::MIPI_DSI0_DATA0_N W MODELTYPE=RLGC N=1
+ Lo=
+ 3.58484574e-07
+ Co=
+ 9.37055974e-11
+ Ro=
+ 4.84133902e+00
+ Go=
+ 0.00000000e+00
+ Rs=
+ 1.72420198e-03
+ Gd=
+ 1.82370500e-11

.Model Wmodel_Trace2228_Auto_88::MIPI_DSI0_DATA0_N W MODELTYPE=RLGC N=1
+ Lo=
+ 3.58484574e-07
+ Co=
+ 9.37055974e-11
+ Ro=
+ 4.84133902e+00
+ Go=
+ 0.00000000e+00
+ Rs=
+ 1.72420198e-03
+ Gd=
+ 1.82370500e-11

.Model Wmodel_Trace2229::MIPI_DSI0_DATA0_N W MODELTYPE=RLGC N=1
+ Lo=
+ 3.58484574e-07
+ Co=
+ 9.37055974e-11
+ Ro=
+ 4.84133902e+00
+ Go=
+ 0.00000000e+00
+ Rs=
+ 1.72420198e-03
+ Gd=
+ 1.82370500e-11

.Model Wmodel_Trace2230::MIPI_DSI0_DATA0_N W MODELTYPE=RLGC N=2
+ Lo=
+ 3.57266790e-07
+ 4.65837360e-08 3.57266790e-07
+ Co=
+ 9.40049686e-11
+ -4.29576828e-12 9.40049686e-11
+ Ro=
+ 4.84133902e+00
+ 0.00000000e+00 4.84133902e+00
+ Go=
+ 0.00000000e+00
+ -0.00000000e+00 0.00000000e+00
+ Rs=
+ 1.72420198e-03
+ -0.00000000e+00 1.72420198e-03
+ Gd=
+ 1.82146888e-11
+ -1.74038681e-13 1.82146888e-11

.Model Wmodel_Trace2230_Auto_52::MIPI_DSI0_DATA0_N W MODELTYPE=RLGC N=1
+ Lo=
+ 3.58484574e-07
+ Co=
+ 9.37055974e-11
+ Ro=
+ 4.84133902e+00
+ Go=
+ 0.00000000e+00
+ Rs=
+ 1.72420198e-03
+ Gd=
+ 1.82370500e-11

.Model Wmodel_Trace2235::MIPI_DSI0_DATA0_N W MODELTYPE=RLGC N=1
+ Lo=
+ 3.32029740e-07
+ Co=
+ 1.03489020e-10
+ Ro=
+ 3.96831067e+00
+ Go=
+ 0.00000000e+00
+ Rs=
+ 1.55902417e-03
+ Gd=
+ 2.04067990e-11

.Model Wmodel_Trace2237::MIPI_DSI0_DATA0_N W MODELTYPE=RLGC N=2
+ Lo=
+ 3.31871609e-07
+ 1.70698835e-08 3.31871609e-07
+ Co=
+ 1.03513645e-10
+ -1.20737356e-12 1.03513645e-10
+ Ro=
+ 3.96831067e+00
+ 0.00000000e+00 3.96831067e+00
+ Go=
+ 0.00000000e+00
+ -0.00000000e+00 0.00000000e+00
+ Rs=
+ 1.55902417e-03
+ -0.00000000e+00 1.55902417e-03
+ Gd=
+ 2.04025621e-11
+ -0.00000000e+00 2.04025621e-11

.Model Wmodel_Trace2245::MIPI_DSI0_DATA0_N W MODELTYPE=RLGC N=1
+ Lo=
+ 3.32029740e-07
+ Co=
+ 1.03489020e-10
+ Ro=
+ 3.96831067e+00
+ Go=
+ 0.00000000e+00
+ Rs=
+ 1.55902417e-03
+ Gd=
+ 2.04067990e-11

.Model Wmodel_Trace2247::MIPI_DSI0_DATA0_N W MODELTYPE=RLGC N=2
+ Lo=
+ 3.31191671e-07
+ 3.52216074e-08 3.31191671e-07
+ Co=
+ 1.03673419e-10
+ -3.41324189e-12 1.03673419e-10
+ Ro=
+ 3.96831067e+00
+ 0.00000000e+00 3.96831067e+00
+ Go=
+ 0.00000000e+00
+ -0.00000000e+00 0.00000000e+00
+ Rs=
+ 1.55902417e-03
+ -0.00000000e+00 1.55902417e-03
+ Gd=
+ 2.03879743e-11
+ -7.30488469e-14 2.03879743e-11

.Model Wmodel_Trace2249::MIPI_DSI0_DATA0_N W MODELTYPE=RLGC N=2
+ Lo=
+ 3.30779497e-07
+ 4.17313211e-08 3.30779497e-07
+ Co=
+ 1.03797855e-10
+ -4.44832318e-12 1.03797855e-10
+ Ro=
+ 3.96831067e+00
+ 0.00000000e+00 3.96831067e+00
+ Go=
+ 0.00000000e+00
+ -0.00000000e+00 0.00000000e+00
+ Rs=
+ 1.55902417e-03
+ -0.00000000e+00 1.55902417e-03
+ Gd=
+ 2.03829873e-11
+ -1.67885007e-13 2.03829873e-11

.Model Wmodel_Trace2250::MIPI_DSI0_DATA0_N W MODELTYPE=RLGC N=1
+ Lo=
+ 3.32029740e-07
+ Co=
+ 1.03489020e-10
+ Ro=
+ 3.96831067e+00
+ Go=
+ 0.00000000e+00
+ Rs=
+ 1.55902417e-03
+ Gd=
+ 2.04067990e-11

.Model Wmodel_Trace2251_Auto_4::MIPI_DSI0_DATA0_N W MODELTYPE=RLGC N=1
+ Lo=
+ 3.32029740e-07
+ Co=
+ 1.03489020e-10
+ Ro=
+ 3.96831067e+00
+ Go=
+ 0.00000000e+00
+ Rs=
+ 1.55902417e-03
+ Gd=
+ 2.04067990e-11

.Model Wmodel_Trace2271::MIPI_DSI0_DATA0_N W MODELTYPE=RLGC N=1
+ Lo=
+ 3.32029740e-07
+ Co=
+ 1.03489020e-10
+ Ro=
+ 3.96831067e+00
+ Go=
+ 0.00000000e+00
+ Rs=
+ 1.55902417e-03
+ Gd=
+ 2.04067990e-11

.Model Wmodel_Trace2273::MIPI_DSI0_DATA0_N W MODELTYPE=RLGC N=1
+ Lo=
+ 3.32029740e-07
+ Co=
+ 1.03489020e-10
+ Ro=
+ 3.96831067e+00
+ Go=
+ 0.00000000e+00
+ Rs=
+ 1.55902417e-03
+ Gd=
+ 2.04067990e-11

.Model Wmodel_Trace2274::MIPI_DSI0_DATA0_N W MODELTYPE=RLGC N=1
+ Lo=
+ 3.32029740e-07
+ Co=
+ 1.03489020e-10
+ Ro=
+ 3.96831067e+00
+ Go=
+ 0.00000000e+00
+ Rs=
+ 1.55902417e-03
+ Gd=
+ 2.04067990e-11

.Model Wmodel_Trace2274_Auto_28::MIPI_DSI0_DATA0_N W MODELTYPE=RLGC N=2
+ Lo=
+ 3.31094797e-07
+ 3.68987568e-08 3.31094797e-07
+ Co=
+ 1.03701156e-10
+ -3.66833433e-12 1.03701156e-10
+ Ro=
+ 3.96831067e+00
+ 0.00000000e+00 3.96831067e+00
+ Go=
+ 0.00000000e+00
+ -0.00000000e+00 0.00000000e+00
+ Rs=
+ 1.55902417e-03
+ -0.00000000e+00 1.55902417e-03
+ Gd=
+ 2.03865489e-11
+ -9.47735856e-14 2.03865489e-11

.Model Wmodel_Trace2274_Auto_30::MIPI_DSI0_DATA0_N W MODELTYPE=RLGC N=2
+ Lo=
+ 3.30748904e-07
+ 4.21593990e-08 3.30748904e-07
+ Co=
+ 1.03807716e-10
+ -4.52055469e-12 1.03807716e-10
+ Ro=
+ 3.96831067e+00
+ 0.00000000e+00 3.96831067e+00
+ Go=
+ 0.00000000e+00
+ -0.00000000e+00 0.00000000e+00
+ Rs=
+ 1.55902417e-03
+ -0.00000000e+00 1.55902417e-03
+ Gd=
+ 2.03827260e-11
+ -1.75097034e-13 2.03827260e-11

.Model Wmodel_Trace2275::MIPI_DSI0_DATA0_N W MODELTYPE=RLGC N=1
+ Lo=
+ 3.32029740e-07
+ Co=
+ 1.03489020e-10
+ Ro=
+ 3.96831067e+00
+ Go=
+ 0.00000000e+00
+ Rs=
+ 1.55902417e-03
+ Gd=
+ 2.04067990e-11

.Model Wmodel_Trace2276#BP0::MIPI_DSI0_DATA0_N W MODELTYPE=RLGC N=2
+ Lo=
+ 3.30838826e-07
+ 4.08829481e-08 3.30838826e-07
+ Co=
+ 1.03778961e-10
+ -4.30666097e-12 1.03778961e-10
+ Ro=
+ 3.96831067e+00
+ 0.00000000e+00 3.96831067e+00
+ Go=
+ 0.00000000e+00
+ -0.00000000e+00 0.00000000e+00
+ Rs=
+ 1.55902417e-03
+ -0.00000000e+00 1.55902417e-03
+ Gd=
+ 2.03835355e-11
+ -1.53940833e-13 2.03835355e-11

.Model Wmodel_Trace2280::MIPI_DSI0_DATA0_N W MODELTYPE=RLGC N=1
+ Lo=
+ 3.32029740e-07
+ Co=
+ 1.03489020e-10
+ Ro=
+ 3.96831067e+00
+ Go=
+ 0.00000000e+00
+ Rs=
+ 1.55902417e-03
+ Gd=
+ 2.04067990e-11

.Model Wmodel_Trace2283::MIPI_DSI0_DATA0_N W MODELTYPE=RLGC N=1
+ Lo=
+ 3.32029740e-07
+ Co=
+ 1.03489020e-10
+ Ro=
+ 3.96831067e+00
+ Go=
+ 0.00000000e+00
+ Rs=
+ 1.55902417e-03
+ Gd=
+ 2.04067990e-11

.Model Wmodel_Trace2284::MIPI_DSI0_DATA0_N W MODELTYPE=RLGC N=1
+ Lo=
+ 3.32029740e-07
+ Co=
+ 1.03489020e-10
+ Ro=
+ 3.96831067e+00
+ Go=
+ 0.00000000e+00
+ Rs=
+ 1.55902417e-03
+ Gd=
+ 2.04067990e-11

.Model Wmodel_Trace2285::MIPI_DSI0_DATA0_N W MODELTYPE=RLGC N=1
+ Lo=
+ 3.32029740e-07
+ Co=
+ 1.03489020e-10
+ Ro=
+ 3.96831067e+00
+ Go=
+ 0.00000000e+00
+ Rs=
+ 1.55902417e-03
+ Gd=
+ 2.04067990e-11

.Model Wmodel_Trace2285_Auto_118::MIPI_DSI0_DATA0_N W MODELTYPE=RLGC N=1
+ Lo=
+ 3.32029740e-07
+ Co=
+ 1.03489020e-10
+ Ro=
+ 3.96831067e+00
+ Go=
+ 0.00000000e+00
+ Rs=
+ 1.55902417e-03
+ Gd=
+ 2.04067990e-11

.Model Wmodel_Trace2287::MIPI_DSI0_DATA0_N W MODELTYPE=RLGC N=1
+ Lo=
+ 3.32029740e-07
+ Co=
+ 1.03489020e-10
+ Ro=
+ 3.96831067e+00
+ Go=
+ 0.00000000e+00
+ Rs=
+ 1.55902417e-03
+ Gd=
+ 2.04067990e-11

.Model Wmodel_Trace2289::MIPI_DSI0_DATA0_N W MODELTYPE=RLGC N=1
+ Lo=
+ 3.32029740e-07
+ Co=
+ 1.03489020e-10
+ Ro=
+ 3.96831067e+00
+ Go=
+ 0.00000000e+00
+ Rs=
+ 1.55902417e-03
+ Gd=
+ 2.04067990e-11

.Model Wmodel_Trace2289_Auto_134::MIPI_DSI0_DATA0_N W MODELTYPE=RLGC N=1
+ Lo=
+ 3.32029740e-07
+ Co=
+ 1.03489020e-10
+ Ro=
+ 3.96831067e+00
+ Go=
+ 0.00000000e+00
+ Rs=
+ 1.55902417e-03
+ Gd=
+ 2.04067990e-11

.Model Wmodel_Trace2289_Auto_136::MIPI_DSI0_DATA0_N W MODELTYPE=RLGC N=1
+ Lo=
+ 3.32029740e-07
+ Co=
+ 1.03489020e-10
+ Ro=
+ 3.96831067e+00
+ Go=
+ 0.00000000e+00
+ Rs=
+ 1.55902417e-03
+ Gd=
+ 2.04067990e-11

.Model Wmodel_Trace2293::MIPI_DSI0_DATA0_N W MODELTYPE=RLGC N=1
+ Lo=
+ 3.32029740e-07
+ Co=
+ 1.03489020e-10
+ Ro=
+ 3.96831067e+00
+ Go=
+ 0.00000000e+00
+ Rs=
+ 1.55902417e-03
+ Gd=
+ 2.04067990e-11

.Model Wmodel_Trace2296_Auto_154::MIPI_DSI0_DATA0_N W MODELTYPE=RLGC N=1
+ Lo=
+ 3.32029740e-07
+ Co=
+ 1.03489020e-10
+ Ro=
+ 3.96831067e+00
+ Go=
+ 0.00000000e+00
+ Rs=
+ 1.55902417e-03
+ Gd=
+ 2.04067990e-11

.Model Wmodel_Trace2304::MIPI_DSI0_DATA0_N W MODELTYPE=RLGC N=1
+ Lo=
+ 3.32029740e-07
+ Co=
+ 1.03489020e-10
+ Ro=
+ 3.96831067e+00
+ Go=
+ 0.00000000e+00
+ Rs=
+ 1.55902417e-03
+ Gd=
+ 2.04067990e-11

.Model Wmodel_Trace2305::MIPI_DSI0_DATA0_N W MODELTYPE=RLGC N=1
+ Lo=
+ 3.32029740e-07
+ Co=
+ 1.03489020e-10
+ Ro=
+ 3.96831067e+00
+ Go=
+ 0.00000000e+00
+ Rs=
+ 1.55902417e-03
+ Gd=
+ 2.04067990e-11

.Model Wmodel_Trace2316::MIPI_DSI0_DATA0_N W MODELTYPE=RLGC N=1
+ Lo=
+ 3.32029740e-07
+ Co=
+ 1.03489020e-10
+ Ro=
+ 3.96831067e+00
+ Go=
+ 0.00000000e+00
+ Rs=
+ 1.55902417e-03
+ Gd=
+ 2.04067990e-11

.Model Wmodel_Trace2319_Auto_209::MIPI_DSI0_DATA0_N W MODELTYPE=RLGC N=1
+ Lo=
+ 3.32029740e-07
+ Co=
+ 1.03489020e-10
+ Ro=
+ 3.96831067e+00
+ Go=
+ 0.00000000e+00
+ Rs=
+ 1.55902417e-03
+ Gd=
+ 2.04067990e-11

.Model Wmodel_Trace2327::MIPI_DSI0_DATA0_N W MODELTYPE=RLGC N=1
+ Lo=
+ 3.32029740e-07
+ Co=
+ 1.03489020e-10
+ Ro=
+ 3.96831067e+00
+ Go=
+ 0.00000000e+00
+ Rs=
+ 1.55902417e-03
+ Gd=
+ 2.04067990e-11

.Model Wmodel_Trace2329::MIPI_DSI0_DATA0_N W MODELTYPE=RLGC N=1
+ Lo=
+ 3.32029740e-07
+ Co=
+ 1.03489020e-10
+ Ro=
+ 3.96831067e+00
+ Go=
+ 0.00000000e+00
+ Rs=
+ 1.55902417e-03
+ Gd=
+ 2.04067990e-11

.Model Wmodel_Trace2333::MIPI_DSI0_DATA0_N W MODELTYPE=RLGC N=1
+ Lo=
+ 3.32029740e-07
+ Co=
+ 1.03489020e-10
+ Ro=
+ 3.96831067e+00
+ Go=
+ 0.00000000e+00
+ Rs=
+ 1.55902417e-03
+ Gd=
+ 2.04067990e-11

.Model Wmodel_Trace2335#BP0::MIPI_DSI0_DATA0_N W MODELTYPE=RLGC N=1
+ Lo=
+ 3.32029740e-07
+ Co=
+ 1.03489020e-10
+ Ro=
+ 3.96831067e+00
+ Go=
+ 0.00000000e+00
+ Rs=
+ 1.55902417e-03
+ Gd=
+ 2.04067990e-11

.Model Wmodel_Trace2335#BP0_Auto_230::MIPI_DSI0_DATA0_N W MODELTYPE=RLGC N=1
+ Lo=
+ 3.32029740e-07
+ Co=
+ 1.03489020e-10
+ Ro=
+ 3.96831067e+00
+ Go=
+ 0.00000000e+00
+ Rs=
+ 1.55902417e-03
+ Gd=
+ 2.04067990e-11

.Model Wmodel_Trace2338::MIPI_DSI0_DATA0_N W MODELTYPE=RLGC N=1
+ Lo=
+ 3.32029740e-07
+ Co=
+ 1.03489020e-10
+ Ro=
+ 3.96831067e+00
+ Go=
+ 0.00000000e+00
+ Rs=
+ 1.55902417e-03
+ Gd=
+ 2.04067990e-11

.Model Wmodel_Trace3056::MIPI_DSI0_DATA0_P W MODELTYPE=RLGC N=1
+ Lo=
+ 3.32029740e-07
+ Co=
+ 1.03489020e-10
+ Ro=
+ 3.96831067e+00
+ Go=
+ 0.00000000e+00
+ Rs=
+ 1.55902417e-03
+ Gd=
+ 2.04067990e-11

.Model Wmodel_Trace3057::MIPI_DSI0_DATA0_P W MODELTYPE=RLGC N=2
+ Lo=
+ 3.31006394e-07
+ 3.83409681e-08 3.31006394e-07
+ Co=
+ 1.03727316e-10
+ -3.89420171e-12 1.03727316e-10
+ Ro=
+ 3.96831067e+00
+ 0.00000000e+00 3.96831067e+00
+ Go=
+ 0.00000000e+00
+ -0.00000000e+00 0.00000000e+00
+ Rs=
+ 1.55902417e-03
+ -0.00000000e+00 1.55902417e-03
+ Gd=
+ 2.03853867e-11
+ -1.14974238e-13 2.03853867e-11

.Model Wmodel_Trace3057_Auto_116::MIPI_DSI0_DATA0_P W MODELTYPE=RLGC N=2
+ Lo=
+ 3.30715126e-07
+ 4.26249921e-08 3.30715126e-07
+ Co=
+ 1.03818694e-10
+ -4.59968437e-12 1.03818694e-10
+ Ro=
+ 3.96831067e+00
+ 0.00000000e+00 3.96831067e+00
+ Go=
+ 0.00000000e+00
+ -0.00000000e+00 0.00000000e+00
+ Rs=
+ 1.55902417e-03
+ -0.00000000e+00 1.55902417e-03
+ Gd=
+ 2.03824542e-11
+ -1.83074221e-13 2.03824542e-11

.Model Wmodel_Trace3059::MIPI_DSI0_DATA0_P W MODELTYPE=RLGC N=1
+ Lo=
+ 3.32029740e-07
+ Co=
+ 1.03489020e-10
+ Ro=
+ 3.96831067e+00
+ Go=
+ 0.00000000e+00
+ Rs=
+ 1.55902417e-03
+ Gd=
+ 2.04067990e-11

.Model Wmodel_Trace3061::MIPI_DSI0_DATA0_P W MODELTYPE=RLGC N=2
+ Lo=
+ 3.30748904e-07
+ 4.21593990e-08 3.30748904e-07
+ Co=
+ 1.03807716e-10
+ -4.52055469e-12 1.03807716e-10
+ Ro=
+ 3.96831067e+00
+ 0.00000000e+00 3.96831067e+00
+ Go=
+ 0.00000000e+00
+ -0.00000000e+00 0.00000000e+00
+ Rs=
+ 1.55902417e-03
+ -0.00000000e+00 1.55902417e-03
+ Gd=
+ 2.03827260e-11
+ -1.75097034e-13 2.03827260e-11

.Model Wmodel_Trace3066::MIPI_DSI0_DATA0_P W MODELTYPE=RLGC N=1
+ Lo=
+ 3.32029740e-07
+ Co=
+ 1.03489020e-10
+ Ro=
+ 3.96831067e+00
+ Go=
+ 0.00000000e+00
+ Rs=
+ 1.55902417e-03
+ Gd=
+ 2.04067990e-11

.Model Wmodel_Trace3071::MIPI_DSI0_DATA0_P W MODELTYPE=RLGC N=1
+ Lo=
+ 3.32029740e-07
+ Co=
+ 1.03489020e-10
+ Ro=
+ 3.96831067e+00
+ Go=
+ 0.00000000e+00
+ Rs=
+ 1.55902417e-03
+ Gd=
+ 2.04067990e-11

.Model Wmodel_Trace3073::MIPI_DSI0_DATA0_P W MODELTYPE=RLGC N=2
+ Lo=
+ 3.31912599e-07
+ 1.49333120e-08 3.31912599e-07
+ Co=
+ 1.03506629e-10
+ -1.01637448e-12 1.03506629e-10
+ Ro=
+ 3.96831067e+00
+ 0.00000000e+00 3.96831067e+00
+ Go=
+ 0.00000000e+00
+ -0.00000000e+00 0.00000000e+00
+ Rs=
+ 1.55902417e-03
+ -0.00000000e+00 1.55902417e-03
+ Gd=
+ 2.04036639e-11
+ -0.00000000e+00 2.04036639e-11

.Model Wmodel_Trace3078::MIPI_DSI0_DATA0_P W MODELTYPE=RLGC N=1
+ Lo=
+ 3.32029740e-07
+ Co=
+ 1.03489020e-10
+ Ro=
+ 3.96831067e+00
+ Go=
+ 0.00000000e+00
+ Rs=
+ 1.55902417e-03
+ Gd=
+ 2.04067990e-11

.Model Wmodel_Trace3083::MIPI_DSI0_DATA0_P W MODELTYPE=RLGC N=1
+ Lo=
+ 3.32029740e-07
+ Co=
+ 1.03489020e-10
+ Ro=
+ 3.96831067e+00
+ Go=
+ 0.00000000e+00
+ Rs=
+ 1.55902417e-03
+ Gd=
+ 2.04067990e-11

.Model Wmodel_Trace3085::MIPI_DSI0_DATA0_P W MODELTYPE=RLGC N=1
+ Lo=
+ 3.32029740e-07
+ Co=
+ 1.03489020e-10
+ Ro=
+ 3.96831067e+00
+ Go=
+ 0.00000000e+00
+ Rs=
+ 1.55902417e-03
+ Gd=
+ 2.04067990e-11

.Model Wmodel_Trace3085_Auto_137::MIPI_DSI0_DATA0_P W MODELTYPE=RLGC N=2
+ Lo=
+ 3.30714981e-07
+ 4.26269783e-08 3.30714981e-07
+ Co=
+ 1.03818741e-10
+ -4.60002320e-12 1.03818741e-10
+ Ro=
+ 3.96831067e+00
+ 0.00000000e+00 3.96831067e+00
+ Go=
+ 0.00000000e+00
+ -0.00000000e+00 0.00000000e+00
+ Rs=
+ 1.55902417e-03
+ -0.00000000e+00 1.55902417e-03
+ Gd=
+ 2.03824531e-11
+ -1.83108547e-13 2.03824531e-11

.Model Wmodel_Trace3085_Auto_139::MIPI_DSI0_DATA0_P W MODELTYPE=RLGC N=1
+ Lo=
+ 3.32029740e-07
+ Co=
+ 1.03489020e-10
+ Ro=
+ 3.96831067e+00
+ Go=
+ 0.00000000e+00
+ Rs=
+ 1.55902417e-03
+ Gd=
+ 2.04067990e-11

.Model Wmodel_Trace3089::MIPI_DSI0_DATA0_P W MODELTYPE=RLGC N=1
+ Lo=
+ 3.32029740e-07
+ Co=
+ 1.03489020e-10
+ Ro=
+ 3.96831067e+00
+ Go=
+ 0.00000000e+00
+ Rs=
+ 1.55902417e-03
+ Gd=
+ 2.04067990e-11

.Model Wmodel_Trace3090::MIPI_DSI0_DATA0_P W MODELTYPE=RLGC N=1
+ Lo=
+ 3.32029740e-07
+ Co=
+ 1.03489020e-10
+ Ro=
+ 3.96831067e+00
+ Go=
+ 0.00000000e+00
+ Rs=
+ 1.55902417e-03
+ Gd=
+ 2.04067990e-11

.Model Wmodel_Trace3090_Auto_153::MIPI_DSI0_DATA0_P W MODELTYPE=RLGC N=2
+ Lo=
+ 3.30679902e-07
+ 4.31029668e-08 3.30679902e-07
+ Co=
+ 1.03830243e-10
+ -4.68153109e-12 1.03830243e-10
+ Ro=
+ 3.96831067e+00
+ 0.00000000e+00 3.96831067e+00
+ Go=
+ 0.00000000e+00
+ -0.00000000e+00 0.00000000e+00
+ Rs=
+ 1.55902417e-03
+ -0.00000000e+00 1.55902417e-03
+ Gd=
+ 2.03821893e-11
+ -1.91407074e-13 2.03821893e-11

.Model Wmodel_Trace3100::MIPI_DSI0_DATA0_P W MODELTYPE=RLGC N=1
+ Lo=
+ 3.32029740e-07
+ Co=
+ 1.03489020e-10
+ Ro=
+ 3.96831067e+00
+ Go=
+ 0.00000000e+00
+ Rs=
+ 1.55902417e-03
+ Gd=
+ 2.04067990e-11

.Model Wmodel_Trace3103::MIPI_DSI0_DATA0_P W MODELTYPE=RLGC N=2
+ Lo=
+ 3.30680333e-07
+ 4.30971638e-08 3.30680333e-07
+ Co=
+ 1.03830101e-10
+ -4.68053370e-12 1.03830101e-10
+ Ro=
+ 3.96831067e+00
+ 0.00000000e+00 3.96831067e+00
+ Go=
+ 0.00000000e+00
+ -0.00000000e+00 0.00000000e+00
+ Rs=
+ 1.55902417e-03
+ -0.00000000e+00 1.55902417e-03
+ Gd=
+ 2.03821924e-11
+ -1.91305038e-13 2.03821924e-11

.Model Wmodel_Trace3103_Auto_198::MIPI_DSI0_DATA0_P W MODELTYPE=RLGC N=1
+ Lo=
+ 3.32029740e-07
+ Co=
+ 1.03489020e-10
+ Ro=
+ 3.96831067e+00
+ Go=
+ 0.00000000e+00
+ Rs=
+ 1.55902417e-03
+ Gd=
+ 2.04067990e-11

.Model Wmodel_Trace3112::MIPI_DSI0_DATA0_P W MODELTYPE=RLGC N=1
+ Lo=
+ 3.32029740e-07
+ Co=
+ 1.03489020e-10
+ Ro=
+ 3.96831067e+00
+ Go=
+ 0.00000000e+00
+ Rs=
+ 1.55902417e-03
+ Gd=
+ 2.04067990e-11

.Model Wmodel_Trace3113::MIPI_DSI0_DATA0_P W MODELTYPE=RLGC N=1
+ Lo=
+ 3.32029740e-07
+ Co=
+ 1.03489020e-10
+ Ro=
+ 3.96831067e+00
+ Go=
+ 0.00000000e+00
+ Rs=
+ 1.55902417e-03
+ Gd=
+ 2.04067990e-11

.Model Wmodel_Trace3113_Auto_208::MIPI_DSI0_DATA0_P W MODELTYPE=RLGC N=2
+ Lo=
+ 3.30679471e-07
+ 4.31087789e-08 3.30679471e-07
+ Co=
+ 1.03830385e-10
+ -4.68253014e-12 1.03830385e-10
+ Ro=
+ 3.96831067e+00
+ 0.00000000e+00 3.96831067e+00
+ Go=
+ 0.00000000e+00
+ -0.00000000e+00 0.00000000e+00
+ Rs=
+ 1.55902417e-03
+ -0.00000000e+00 1.55902417e-03
+ Gd=
+ 2.03821862e-11
+ -1.91509291e-13 2.03821862e-11

.Model Wmodel_Trace3123::MIPI_DSI0_DATA0_P W MODELTYPE=RLGC N=1
+ Lo=
+ 3.32029740e-07
+ Co=
+ 1.03489020e-10
+ Ro=
+ 3.96831067e+00
+ Go=
+ 0.00000000e+00
+ Rs=
+ 1.55902417e-03
+ Gd=
+ 2.04067990e-11

.Model Wmodel_Trace3125::MIPI_DSI0_DATA0_P W MODELTYPE=RLGC N=2
+ Lo=
+ 3.30680333e-07
+ 4.30971638e-08 3.30680333e-07
+ Co=
+ 1.03830101e-10
+ -4.68053370e-12 1.03830101e-10
+ Ro=
+ 3.96831067e+00
+ 0.00000000e+00 3.96831067e+00
+ Go=
+ 0.00000000e+00
+ -0.00000000e+00 0.00000000e+00
+ Rs=
+ 1.55902417e-03
+ -0.00000000e+00 1.55902417e-03
+ Gd=
+ 2.03821924e-11
+ -1.91305038e-13 2.03821924e-11

.Model Wmodel_Trace3125_Auto_216::MIPI_DSI0_DATA0_P W MODELTYPE=RLGC N=1
+ Lo=
+ 3.32029740e-07
+ Co=
+ 1.03489020e-10
+ Ro=
+ 3.96831067e+00
+ Go=
+ 0.00000000e+00
+ Rs=
+ 1.55902417e-03
+ Gd=
+ 2.04067990e-11

.Model Wmodel_Trace3129::MIPI_DSI0_DATA0_P W MODELTYPE=RLGC N=1
+ Lo=
+ 3.32029740e-07
+ Co=
+ 1.03489020e-10
+ Ro=
+ 3.96831067e+00
+ Go=
+ 0.00000000e+00
+ Rs=
+ 1.55902417e-03
+ Gd=
+ 2.04067990e-11

.Model Wmodel_Trace3131::MIPI_DSI0_DATA0_P W MODELTYPE=RLGC N=1
+ Lo=
+ 3.32029740e-07
+ Co=
+ 1.03489020e-10
+ Ro=
+ 3.96831067e+00
+ Go=
+ 0.00000000e+00
+ Rs=
+ 1.55902417e-03
+ Gd=
+ 2.04067990e-11

.Model Wmodel_Trace3131_Auto_217::MIPI_DSI0_DATA0_P W MODELTYPE=RLGC N=2
+ Lo=
+ 3.30748990e-07
+ 4.21581973e-08 3.30748990e-07
+ Co=
+ 1.03807688e-10
+ -4.52035123e-12 1.03807688e-10
+ Ro=
+ 3.96831067e+00
+ 0.00000000e+00 3.96831067e+00
+ Go=
+ 0.00000000e+00
+ -0.00000000e+00 0.00000000e+00
+ Rs=
+ 1.55902417e-03
+ -0.00000000e+00 1.55902417e-03
+ Gd=
+ 2.03827267e-11
+ -1.75076625e-13 2.03827267e-11

.Model Wmodel_Trace3132::MIPI_DSI0_DATA0_P W MODELTYPE=RLGC N=1
+ Lo=
+ 3.32029740e-07
+ Co=
+ 1.03489020e-10
+ Ro=
+ 3.96831067e+00
+ Go=
+ 0.00000000e+00
+ Rs=
+ 1.55902417e-03
+ Gd=
+ 2.04067990e-11

.Model Wmodel_Trace3133::MIPI_DSI0_DATA0_P W MODELTYPE=RLGC N=2
+ Lo=
+ 3.31111858e-07
+ 3.66111712e-08 3.31111858e-07
+ Co=
+ 1.03696199e-10
+ -3.62401113e-12 1.03696199e-10
+ Ro=
+ 3.96831067e+00
+ 0.00000000e+00 3.96831067e+00
+ Go=
+ 0.00000000e+00
+ -0.00000000e+00 0.00000000e+00
+ Rs=
+ 1.55902417e-03
+ -0.00000000e+00 1.55902417e-03
+ Gd=
+ 2.03867883e-11
+ -9.09127903e-14 2.03867883e-11

.Model Wmodel_Trace3137::MIPI_DSI0_DATA0_P W MODELTYPE=RLGC N=1
+ Lo=
+ 3.32029740e-07
+ Co=
+ 1.03489020e-10
+ Ro=
+ 3.96831067e+00
+ Go=
+ 0.00000000e+00
+ Rs=
+ 1.55902417e-03
+ Gd=
+ 2.04067990e-11

.Model Wmodel_Trace3140::MIPI_DSI0_DATA0_P W MODELTYPE=RLGC N=1
+ Lo=
+ 3.32029740e-07
+ Co=
+ 1.03489020e-10
+ Ro=
+ 3.96831067e+00
+ Go=
+ 0.00000000e+00
+ Rs=
+ 1.55902417e-03
+ Gd=
+ 2.04067990e-11

.Model Wmodel_Trace3141_Auto_29::MIPI_DSI0_DATA0_P W MODELTYPE=RLGC N=1
+ Lo=
+ 3.32029740e-07
+ Co=
+ 1.03489020e-10
+ Ro=
+ 3.96831067e+00
+ Go=
+ 0.00000000e+00
+ Rs=
+ 1.55902417e-03
+ Gd=
+ 2.04067990e-11

.Model Wmodel_Trace3142::MIPI_DSI0_DATA0_P W MODELTYPE=RLGC N=1
+ Lo=
+ 3.32029740e-07
+ Co=
+ 1.03489020e-10
+ Ro=
+ 3.96831067e+00
+ Go=
+ 0.00000000e+00
+ Rs=
+ 1.55902417e-03
+ Gd=
+ 2.04067990e-11

.Model Wmodel_Trace3144::MIPI_DSI0_DATA0_P W MODELTYPE=RLGC N=2
+ Lo=
+ 3.30762906e-07
+ 4.19642357e-08 3.30762906e-07
+ Co=
+ 1.03803192e-10
+ -4.48756170e-12 1.03803192e-10
+ Ro=
+ 3.96831067e+00
+ 0.00000000e+00 3.96831067e+00
+ Go=
+ 0.00000000e+00
+ -0.00000000e+00 0.00000000e+00
+ Rs=
+ 1.55902417e-03
+ -0.00000000e+00 1.55902417e-03
+ Gd=
+ 2.03828438e-11
+ -1.71794447e-13 2.03828438e-11

.Model Wmodel_Trace3144_Auto_97::MIPI_DSI0_DATA0_P W MODELTYPE=RLGC N=1
+ Lo=
+ 3.32029740e-07
+ Co=
+ 1.03489020e-10
+ Ro=
+ 3.96831067e+00
+ Go=
+ 0.00000000e+00
+ Rs=
+ 1.55902417e-03
+ Gd=
+ 2.04067990e-11

.Model Wmodel_Trace3164::MIPI_DSI0_DATA0_P W MODELTYPE=RLGC N=1
+ Lo=
+ 3.32029740e-07
+ Co=
+ 1.03489020e-10
+ Ro=
+ 3.96831067e+00
+ Go=
+ 0.00000000e+00
+ Rs=
+ 1.55902417e-03
+ Gd=
+ 2.04067990e-11

.Model Wmodel_Trace3166::MIPI_DSI0_DATA0_P W MODELTYPE=RLGC N=1
+ Lo=
+ 3.32029740e-07
+ Co=
+ 1.03489020e-10
+ Ro=
+ 3.96831067e+00
+ Go=
+ 0.00000000e+00
+ Rs=
+ 1.55902417e-03
+ Gd=
+ 2.04067990e-11

.Model Wmodel_Trace3166_Auto_3::MIPI_DSI0_DATA0_P W MODELTYPE=RLGC N=2
+ Lo=
+ 3.30761892e-07
+ 4.19784085e-08 3.30761892e-07
+ Co=
+ 1.03803519e-10
+ -4.48995415e-12 1.03803519e-10
+ Ro=
+ 3.96831067e+00
+ 0.00000000e+00 3.96831067e+00
+ Go=
+ 0.00000000e+00
+ -0.00000000e+00 0.00000000e+00
+ Rs=
+ 1.55902417e-03
+ -0.00000000e+00 1.55902417e-03
+ Gd=
+ 2.03828352e-11
+ -1.72033459e-13 2.03828352e-11

.Model Wmodel_Trace3167::MIPI_DSI0_DATA0_P W MODELTYPE=RLGC N=2
+ Lo=
+ 3.30748904e-07
+ 4.21593990e-08 3.30748904e-07
+ Co=
+ 1.03807716e-10
+ -4.52055469e-12 1.03807716e-10
+ Ro=
+ 3.96831067e+00
+ 0.00000000e+00 3.96831067e+00
+ Go=
+ 0.00000000e+00
+ -0.00000000e+00 0.00000000e+00
+ Rs=
+ 1.55902417e-03
+ -0.00000000e+00 1.55902417e-03
+ Gd=
+ 2.03827260e-11
+ -1.75097034e-13 2.03827260e-11

.Model Wmodel_Trace3167_Auto_27::MIPI_DSI0_DATA0_P W MODELTYPE=RLGC N=1
+ Lo=
+ 3.32029740e-07
+ Co=
+ 1.03489020e-10
+ Ro=
+ 3.96831067e+00
+ Go=
+ 0.00000000e+00
+ Rs=
+ 1.55902417e-03
+ Gd=
+ 2.04067990e-11

.Model Wmodel_Trace3168::MIPI_DSI0_DATA0_P W MODELTYPE=RLGC N=1
+ Lo=
+ 3.32029740e-07
+ Co=
+ 1.03489020e-10
+ Ro=
+ 3.96831067e+00
+ Go=
+ 0.00000000e+00
+ Rs=
+ 1.55902417e-03
+ Gd=
+ 2.04067990e-11

.Model Wmodel_Trace3168_Auto_33::MIPI_DSI0_DATA0_P W MODELTYPE=RLGC N=1
+ Lo=
+ 3.32029740e-07
+ Co=
+ 1.03489020e-10
+ Ro=
+ 3.96831067e+00
+ Go=
+ 0.00000000e+00
+ Rs=
+ 1.55902417e-03
+ Gd=
+ 2.04067990e-11

.Model Wmodel_Trace3193::MIPI_DSI0_DATA0_P W MODELTYPE=RLGC N=1
+ Lo=
+ 3.32029740e-07
+ Co=
+ 1.03489020e-10
+ Ro=
+ 3.96831067e+00
+ Go=
+ 0.00000000e+00
+ Rs=
+ 1.55902417e-03
+ Gd=
+ 2.04067990e-11

.Model Wmodel_Trace3195::MIPI_DSI0_DATA0_P W MODELTYPE=RLGC N=1
+ Lo=
+ 3.32029740e-07
+ Co=
+ 1.03489020e-10
+ Ro=
+ 3.96831067e+00
+ Go=
+ 0.00000000e+00
+ Rs=
+ 1.55902417e-03
+ Gd=
+ 2.04067990e-11

.Model Wmodel_Trace3195_Auto_28::MIPI_DSI0_DATA0_P W MODELTYPE=RLGC N=1
+ Lo=
+ 3.32029740e-07
+ Co=
+ 1.03489020e-10
+ Ro=
+ 3.96831067e+00
+ Go=
+ 0.00000000e+00
+ Rs=
+ 1.55902417e-03
+ Gd=
+ 2.04067990e-11

.Model Wmodel_Trace3197::MIPI_DSI0_DATA0_P W MODELTYPE=RLGC N=1
+ Lo=
+ 3.58484574e-07
+ Co=
+ 9.37055974e-11
+ Ro=
+ 4.84133902e+00
+ Go=
+ 0.00000000e+00
+ Rs=
+ 1.72420198e-03
+ Gd=
+ 1.82370500e-11

.Model Wmodel_Trace3198::MIPI_DSI0_DATA0_P W MODELTYPE=RLGC N=1
+ Lo=
+ 3.58484574e-07
+ Co=
+ 9.37055974e-11
+ Ro=
+ 4.84133902e+00
+ Go=
+ 0.00000000e+00
+ Rs=
+ 1.72420198e-03
+ Gd=
+ 1.82370500e-11

.Model Wmodel_Trace3199::MIPI_DSI0_DATA0_P W MODELTYPE=RLGC N=1
+ Lo=
+ 3.58484574e-07
+ Co=
+ 9.37055974e-11
+ Ro=
+ 4.84133902e+00
+ Go=
+ 0.00000000e+00
+ Rs=
+ 1.72420198e-03
+ Gd=
+ 1.82370500e-11

.Model Wmodel_Trace3200::MIPI_DSI0_DATA0_P W MODELTYPE=RLGC N=2
+ Lo=
+ 3.56785306e-07
+ 5.37198793e-08 3.56785306e-07
+ Co=
+ 9.41700896e-11
+ -5.38576608e-12 9.41700896e-11
+ Ro=
+ 4.84133902e+00
+ 0.00000000e+00 4.84133902e+00
+ Go=
+ 0.00000000e+00
+ -0.00000000e+00 0.00000000e+00
+ Rs=
+ 1.72420198e-03
+ -0.00000000e+00 1.72420198e-03
+ Gd=
+ 1.82126203e-11
+ -2.91337540e-13 1.82126203e-11
